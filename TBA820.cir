.title KiCad schematic
U4 beforeC4 plot_v1
C4 beforeC4 Output 220u
U3 Output plot_v1
R10 Output Vs 4k
C6 beforeC4 Net-_C6-Pad2_ 330p
Q18 Vs Net-_Q17-Pad3_ beforeC4 eSim_NPN
Q16 Net-_D3-Pad1_ Net-_Q12-Pad2_ Output eSim_PNP
D2 Net-_D1-Pad2_ Net-_D2-Pad2_ eSim_Diode
R7 beforeC4 Net-_Q10-Pad1_ 6k
D1 Net-_D1-Pad1_ Net-_D1-Pad2_ eSim_Diode
R8 beforeC4 Net-_Q17-Pad3_ 2k
Q17 Output Net-_D1-Pad1_ Net-_Q17-Pad3_ eSim_NPN
D4 Net-_D3-Pad2_ beforeC4 eSim_Diode
D3 Net-_D3-Pad1_ Net-_D3-Pad2_ eSim_Diode
U2 Vs plot_v1
v2 Vs GND DC
C5 Vs GND 0.1u
C2 GND Vs 100u
Q13 Net-_Q13-Pad1_ Net-_D2-Pad2_ Net-_Q13-Pad3_ eSim_PNP
Q14 Vs Net-_D3-Pad1_ Net-_Q13-Pad3_ eSim_NPN
Q11 Net-_D2-Pad2_ Net-_C6-Pad2_ GND eSim_NPN
R9 Net-_C3-Pad1_ beforeC4 1k
C3 Net-_C3-Pad1_ GND 0.22u
Q15 beforeC4 Net-_Q13-Pad1_ GND eSim_NPN
C7 Net-_C7-Pad1_ Vs 47u
R5 GND Net-_Q10-Pad2_ 2k
Q8 Net-_Q7-Pad2_ Net-_Q10-Pad2_ GND eSim_NPN
Q3 Net-_C6-Pad2_ Net-_Q3-Pad2_ GND eSim_NPN
Q5 Net-_Q3-Pad2_ Net-_Q3-Pad2_ GND eSim_NPN
Q7 Net-_Q12-Pad2_ Net-_Q7-Pad2_ Net-_Q10-Pad2_ eSim_NPN
R1 GND Input 10k
Q10 Net-_Q10-Pad1_ Net-_Q10-Pad2_ GND eSim_NPN
Q12 Net-_D1-Pad1_ Net-_Q12-Pad2_ Output eSim_PNP
R6 Net-_C1-Pad2_ Net-_Q10-Pad1_ 120
C1 GND Net-_C1-Pad2_ 100u
Q1 GND Net-_Q1-Pad2_ Net-_Q1-Pad3_ eSim_PNP
U1 Input plot_v1
R2 Input Net-_Q1-Pad2_ 2k
Q4 Net-_Q2-Pad3_ Net-_Q12-Pad2_ Output eSim_PNP
Q6 Net-_Q3-Pad2_ Net-_Q10-Pad1_ Net-_Q2-Pad3_ eSim_PNP
Q2 Net-_C6-Pad2_ Net-_Q1-Pad3_ Net-_Q2-Pad3_ eSim_PNP
v1 GND Input sine
R4 Net-_Q7-Pad2_ Net-_C7-Pad1_ 6k
R3 Net-_C7-Pad1_ Vs 5.9k
Q9 Net-_Q12-Pad2_ Net-_Q12-Pad2_ Output eSim_PNP
.end
