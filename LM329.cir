.title KiCad schematic
R5 GND b 2k
R4 Net-_C2-Pad2_ b 10k
C2 Net-_C2-Pad1_ Net-_C2-Pad2_ 30p
Q4 Net-_C2-Pad1_ Net-_C2-Pad2_ GND eSim_NPN
R6 Net-_Q5-Pad3_ out 1k
U1 b out zener
Q2 out out Net-_C1-Pad1_ eSim_NPN
R2 Net-_C1-Pad2_ Net-_Q1-Pad2_ 2k
Q3 Net-_Q1-Pad2_ Net-_C2-Pad1_ Net-_C1-Pad1_ eSim_PNP
Q1 Net-_C1-Pad1_ Net-_Q1-Pad2_ GND eSim_NPN
C1 Net-_C1-Pad1_ Net-_C1-Pad2_ 15p
R1 Net-_C1-Pad1_ out 50
R3 GND Net-_Q1-Pad2_ 30k
Q6 Net-_Q5-Pad2_ b c eSim_NPN
U5 c plot_v1
U4 b plot_v1
Q5 Net-_C2-Pad1_ Net-_Q5-Pad2_ Net-_Q5-Pad3_ eSim_PNP
Q7 Net-_Q5-Pad2_ Net-_Q5-Pad2_ out eSim_PNP
U2 in plot_v1
R8 out in 6.8k
U3 out plot_v1
R7 GND c 2.6k
v1 in GND DC
.end
