.title KiCad schematic
U38 Net-_U20-Pad3_ Net-_U15-Pad3_ Net-_U38-Pad3_ d_and
U41 Net-_U16-Pad3_ Net-_U41-Pad2_ d_buffer
U23 Net-_U18-Pad3_ Net-_U23-Pad2_ d_inverter
U37 Net-_U19-Pad3_ Net-_U17-Pad2_ Net-_U37-Pad3_ d_and
U51 Net-_U36-Pad3_ Net-_U37-Pad3_ Net-_U51-Pad3_ d_and
U45 Net-_U14-Pad3_ Net-_U23-Pad2_ Net-_U45-Pad3_ d_and
U36 Net-_U18-Pad3_ Net-_U15-Pad3_ Net-_U36-Pad3_ d_and
U52 Net-_U35-Pad3_ Net-_U19-Pad3_ Net-_U52-Pad3_ d_and
U35 Net-_U20-Pad3_ Net-_U18-Pad3_ Net-_U35-Pad3_ d_and
U24 Net-_U16-Pad3_ Net-_U24-Pad2_ d_inverter
U42 Net-_U19-Pad3_ Net-_U17-Pad2_ Net-_U42-Pad3_ d_and
U39 Net-_U15-Pad3_ Net-_U19-Pad3_ Net-_U39-Pad3_ d_and
U26 Net-_U17-Pad2_ Net-_U26-Pad2_ d_inverter
U25 Net-_U20-Pad3_ Net-_U25-Pad2_ d_inverter
U47 Net-_U19-Pad3_ Net-_U25-Pad2_ Net-_U47-Pad3_ d_and
U43 Net-_U43-Pad1_ E1 dac_bridge_1
U21 E1 plot_v1
U54 Net-_U47-Pad3_ Net-_U26-Pad2_ Net-_U43-Pad1_ d_xor
U46 Net-_U15-Pad3_ Net-_U24-Pad2_ Net-_U46-Pad3_ d_and
U53 Net-_U39-Pad3_ Net-_U17-Pad2_ Net-_U53-Pad3_ d_and
U49 Net-_U30-Pad3_ Net-_U31-Pad3_ Net-_U49-Pad3_ d_and
U48 Net-_U29-Pad3_ Net-_U18-Pad3_ Net-_U48-Pad3_ d_and
U50 Net-_U32-Pad3_ Net-_U33-Pad3_ Net-_U50-Pad3_ d_and
U34 Net-_U16-Pad3_ Net-_U18-Pad3_ Net-_U34-Pad3_ d_and
U40 Net-_U18-Pad3_ Net-_U40-Pad2_ d_buffer
U44 Net-_U12-Pad3_ Net-_U22-Pad2_ Net-_U44-Pad3_ d_and
U22 Net-_U13-Pad3_ Net-_U22-Pad2_ d_inverter
U32 Net-_U12-Pad3_ Net-_U18-Pad3_ Net-_U32-Pad3_ d_and
U30 Net-_U20-Pad3_ Net-_U12-Pad3_ Net-_U30-Pad3_ d_and
U31 Net-_U18-Pad3_ Net-_U15-Pad3_ Net-_U31-Pad3_ d_and
U33 Net-_U15-Pad3_ Net-_U19-Pad3_ Net-_U33-Pad3_ d_and
U70 Net-_U65-Pad3_ Net-_U70-Pad2_ d_inverter
U69 Net-_U46-Pad3_ Net-_U62-Pad3_ Net-_U69-Pad3_ d_xor
U66 Net-_U63-Pad3_ Net-_U66-Pad2_ d_inverter
U67 Net-_U44-Pad3_ Net-_U66-Pad2_ Net-_U67-Pad3_ d_xor
U74 Net-_U45-Pad3_ Net-_U70-Pad2_ Net-_U73-Pad3_ d_xor
U73 Net-_U71-Pad2_ Net-_U67-Pad3_ Net-_U73-Pad3_ Net-_U69-Pad3_ C4 E4 E3 E2 dac_bridge_4
U77 E3 plot_v1
U76 E2 plot_v1
U58 Net-_U50-Pad3_ Net-_U17-Pad2_ Net-_U58-Pad3_ d_and
U60 Net-_U48-Pad3_ Net-_U49-Pad3_ Net-_U60-Pad3_ d_or
U59 Net-_U27-Pad2_ Net-_U28-Pad3_ Net-_U59-Pad3_ d_or
U64 Net-_U59-Pad3_ Net-_U60-Pad3_ Net-_U64-Pad3_ d_or
U68 Net-_U64-Pad3_ Net-_U58-Pad3_ Net-_U68-Pad3_ d_or
U71 Net-_U68-Pad3_ Net-_U71-Pad2_ d_inverter
U72 C4 plot_v1
U75 E4 plot_v1
U55 Net-_U20-Pad3_ Net-_U55-Pad2_ d_buffer
U56 Net-_U40-Pad2_ Net-_U34-Pad3_ Net-_U56-Pad3_ d_or
U57 Net-_U52-Pad3_ Net-_U51-Pad3_ Net-_U57-Pad3_ d_or
U61 Net-_U38-Pad3_ Net-_U53-Pad3_ Net-_U61-Pad3_ d_or
U65 Net-_U41-Pad2_ Net-_U61-Pad3_ Net-_U65-Pad3_ d_or
U62 Net-_U55-Pad2_ Net-_U42-Pad3_ Net-_U62-Pad3_ d_nor
U63 Net-_U56-Pad3_ Net-_U57-Pad3_ Net-_U63-Pad3_ d_or
U29 Net-_U16-Pad3_ Net-_U12-Pad3_ Net-_U29-Pad3_ d_and
U28 Net-_U18-Pad3_ Net-_U12-Pad3_ Net-_U28-Pad3_ d_and
U27 Net-_U13-Pad3_ Net-_U27-Pad2_ d_buffer
U18 Net-_U14-Pad1_ Net-_U14-Pad2_ Net-_U18-Pad3_ d_nor
U14 Net-_U14-Pad1_ Net-_U14-Pad2_ Net-_U14-Pad3_ d_nand
U15 Net-_U15-Pad1_ Net-_U15-Pad2_ Net-_U15-Pad3_ d_nand
U16 Net-_U15-Pad1_ Net-_U15-Pad2_ Net-_U16-Pad3_ d_nor
U19 Net-_U19-Pad1_ Net-_U19-Pad2_ Net-_U19-Pad3_ d_nand
U11 B4 plot_v1
v8 A4 GND pulse
v9 B4 GND pulse
U13 Net-_U12-Pad1_ Net-_U12-Pad2_ Net-_U13-Pad3_ d_nor
U12 Net-_U12-Pad1_ Net-_U12-Pad2_ Net-_U12-Pad3_ d_nand
U4 B4 A4 B3 A3 B2 A2 B1 A1 Net-_U12-Pad1_ Net-_U12-Pad2_ Net-_U14-Pad1_ Net-_U14-Pad2_ Net-_U15-Pad1_ Net-_U15-Pad2_ Net-_U19-Pad1_ Net-_U19-Pad2_ adc_bridge_8
U17 Net-_U17-Pad1_ Net-_U17-Pad2_ d_inverter
U20 Net-_U19-Pad1_ Net-_U19-Pad2_ Net-_U20-Pad3_ d_nor
U6 C0 Net-_U17-Pad1_ adc_bridge_1
v4 C0 GND pulse
U1 C0 plot_v1
U9 B3 plot_v1
v2 B2 GND pulse
U7 A3 plot_v1
U3 B2 plot_v1
U10 A4 plot_v1
v7 B3 GND pulse
v5 A3 GND pulse
U2 A2 plot_v1
v3 B1 GND pulse
v1 A2 GND pulse
v6 A1 GND pulse
U5 B1 plot_v1
U8 A1 plot_v1
.end
