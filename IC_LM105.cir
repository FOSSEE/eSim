.title KiCad schematic
R4 Net-_Q7-Pad1_ Net-_Q12-Pad2_ 2.85k
R3 Net-_Q12-Pad2_ Net-_Q10-Pad2_ 6.8k
C1 Net-_C1-Pad1_ Net-_C1-Pad2_ 5p
Q12 Net-_C1-Pad1_ Net-_Q12-Pad2_ Net-_Q12-Pad3_ eSim_NPN
Q16 Net-_Q10-Pad3_ Net-_Q16-Pad2_ Net-_Q12-Pad3_ eSim_NPN
Q7 Net-_Q7-Pad1_ Net-_Q7-Pad1_ Net-_C1-Pad2_ eSim_NPN
U2 Net-_Q20-Pad3_ Net-_Q20-Pad1_ r Net-_C1-Pad2_ Net-_Q12-Pad2_ Net-_Q16-Pad2_ Net-_Q14-Pad1_ Net-_Q18-Pad3_ PORT
Q14 Net-_Q14-Pad1_ Net-_C1-Pad1_ Net-_Q10-Pad3_ eSim_NPN
Q19 Net-_Q14-Pad1_ Net-_Q16-Pad2_ Net-_Q12-Pad2_ eSim_NPN
R6 Net-_C1-Pad2_ Net-_Q12-Pad3_ 2.2k
M1 Net-_M1-Pad1_ Net-_C1-Pad2_ Net-_C1-Pad2_ Net-_C1-Pad2_ mosfet_n
U1 Net-_C1-Pad2_ Net-_Q4-Pad1_ zener
Q20 Net-_Q20-Pad1_ Net-_Q17-Pad3_ Net-_Q20-Pad3_ eSim_NPN
R8 Net-_Q20-Pad3_ Net-_Q18-Pad2_ 1.32k
Q17 r Net-_Q15-Pad1_ Net-_Q17-Pad3_ eSim_NPN
Q13 Net-_M1-Pad1_ Net-_Q13-Pad2_ Net-_Q13-Pad3_ eSim_NPN
R7 Net-_Q18-Pad2_ Net-_Q17-Pad3_ 1.86k
R9 r Net-_Q20-Pad1_ 600
Q18 Net-_Q15-Pad1_ Net-_Q18-Pad2_ Net-_Q18-Pad3_ eSim_NPN
R5 Net-_C1-Pad1_ Net-_Q13-Pad3_ 4.4k
Q15 Net-_Q15-Pad1_ Net-_Q15-Pad1_ Net-_Q14-Pad1_ eSim_NPN
Q11 Net-_Q11-Pad1_ Net-_Q11-Pad2_ Net-_Q10-Pad1_ eSim_NPN
Q6 Net-_Q13-Pad2_ Net-_Q13-Pad2_ Net-_Q6-Pad3_ eSim_NPN
R2 Net-_Q10-Pad2_ Net-_Q6-Pad3_ 3k
Q8 Net-_Q11-Pad1_ Net-_Q11-Pad2_ Net-_Q6-Pad3_ eSim_NPN
Q10 Net-_Q10-Pad1_ Net-_Q10-Pad2_ Net-_Q10-Pad3_ eSim_NPN
Q5 Net-_Q3-Pad1_ Net-_Q4-Pad1_ Net-_Q13-Pad2_ eSim_NPN
Q1 Net-_Q1-Pad1_ Net-_Q1-Pad1_ Net-_M1-Pad1_ eSim_NPN
Q2 Net-_Q15-Pad1_ Net-_Q1-Pad1_ r eSim_PNP
R1 Net-_Q1-Pad1_ Net-_Q3-Pad1_ 2.8k
Q9 r Net-_Q3-Pad1_ Net-_Q11-Pad1_ eSim_NPN
Q3 Net-_Q3-Pad1_ Net-_Q1-Pad1_ r eSim_PNP
Q4 Net-_Q4-Pad1_ Net-_Q1-Pad1_ r eSim_PNP
.end
