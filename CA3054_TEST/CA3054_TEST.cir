.title KiCad schematic
R2 Net-_C1-Pad1_ out1 1k
X1 unconnected-_X1-Pad1_ unconnected-_X1-Pad2_ unconnected-_X1-Pad3_ unconnected-_X1-Pad4_ unconnected-_X1-Pad5_ Net-_R1-Pad2_ out1 out2 Net-_C2-Pad1_ unconnected-_X1-Pad10_ Vx Net-_R4-Pad1_ unconnected-_X1-Pad13_ unconnected-_X1-Pad14_ CA3054
U2 out1 plot_v1
R1 GND Net-_R1-Pad2_ 1k
C1 Net-_C1-Pad1_ GND 0.1u
v1 Net-_C1-Pad1_ GND DC
R4 Net-_R4-Pad1_ Net-_C3-Pad1_ 0.5k
U3 out2 plot_v1
v2 Net-_R3-Pad1_ GND DC
R3 Net-_R3-Pad1_ out2 1k
U1 Vx plot_v1
R6 Vx GND 1k
R5 GND Net-_C2-Pad1_ 1k
C2 Net-_C2-Pad1_ inp 10u
C3 Net-_C3-Pad1_ GND 0.1u
U4 inp plot_v1
v4 Net-_C3-Pad1_ GND DC
v3 inp GND sine
.end
