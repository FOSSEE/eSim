.title KiCad schematic
Q15 Net-_Q13-Pad2_ Net-_I1-Pad2_ Net-_Q15-Pad3_ eSim_NPN
Q16 Net-_I1-Pad2_ Net-_I1-Pad2_ Net-_Q16-Pad3_ eSim_NPN
R12 GND Net-_Q15-Pad3_ 10k
R13 GND Net-_Q16-Pad3_ 10k
Q8 Net-_Q5-Pad3_ Net-_I1-Pad2_ Net-_Q8-Pad3_ eSim_NPN
R9 GND Net-_Q8-Pad3_ 10k
Q6 Net-_Q11-Pad2_ Net-_Q10-Pad1_ Net-_Q6-Pad3_ eSim_PNP
D1 output Net-_D1-Pad2_ eSim_Diode
R5 Net-_Q3-Pad1_ Net-_D1-Pad2_ 16k
R6 Net-_R4-Pad2_ Net-_Q3-Pad3_ 1k
R4 GND Net-_R4-Pad2_ 10k
R7 GND Net-_R4-Pad2_ 10k
Q2 Net-_C1-Pad2_ Net-_R3-Pad1_ e eSim_NPN
Q3 Net-_Q3-Pad1_ q19 Net-_Q3-Pad3_ eSim_NPN
U6 q19 plot_v1
R3 Net-_R3-Pad1_ q19 5k
R16 GND q19 10k
U5 e plot_v1
Q1 Net-_C1-Pad2_ Net-_R3-Pad1_ e eSim_NPN
R1 Net-_Q3-Pad3_ e 17k
R2 Net-_C1-Pad2_ Net-_D1-Pad2_ 51k
U2 input plot_v1
v1 input GND DC
Q19 Net-_Q17-Pad3_ Net-_Q18-Pad3_ output eSim_NPN
U1 output plot_v1
R14 Net-_Q17-Pad3_ input 1k
C3 input GND 0.1u
I1 input Net-_I1-Pad2_ 50u
Q17 Net-_Q13-Pad3_ input Net-_Q17-Pad3_ eSim_NPN
Q18 Net-_Q17-Pad3_ dv1 Net-_Q18-Pad3_ eSim_NPN
D3 dv2 Net-_D3-Pad2_ eSim_Diode
R17 unconnected-_R17-Pad1_ q19 100k
Q14 Net-_Q13-Pad2_ Net-_Q13-Pad2_ input eSim_PNP
C2 output GND 0.1u
R15 q19 output 73k
Q10 Net-_Q10-Pad1_ Net-_Q10-Pad1_ Net-_Q10-Pad3_ eSim_PNP
R8 Net-_Q6-Pad3_ input 10k
R10 Net-_Q10-Pad3_ input 10k
R11 Net-_Q13-Pad3_ input 10k
Q13 dv1 Net-_Q13-Pad2_ Net-_Q13-Pad3_ eSim_PNP
U3 dv2 plot_v1
D2 dv1 dv2 eSim_Diode
U4 dv1 plot_v1
Q12 GND Net-_C1-Pad1_ Net-_D3-Pad2_ eSim_PNP
C1 Net-_C1-Pad1_ Net-_C1-Pad2_ 30p
Q7 Net-_C1-Pad1_ Net-_D1-Pad2_ Net-_Q7-Pad3_ eSim_NPN
Q4 Net-_Q11-Pad2_ Net-_D1-Pad2_ Net-_Q4-Pad3_ eSim_NPN
Q5 Net-_Q4-Pad3_ Net-_Q3-Pad1_ Net-_Q5-Pad3_ eSim_NPN
Q9 Net-_Q7-Pad3_ Net-_C1-Pad2_ Net-_Q5-Pad3_ eSim_NPN
Q11 Net-_C1-Pad1_ Net-_Q11-Pad2_ Net-_Q10-Pad1_ eSim_PNP
.end
