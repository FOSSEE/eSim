V1 in 0 DC 5
R1 in out 1k
C1 out 0 1u
R2 out 0 1Meg

.control
run
.endc

.tran 1ms 10ms
.end
