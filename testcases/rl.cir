V1 in 0 DC 5
R1 in out 1k
L1 out 0 1m

.control
run
.endc

.tran 1ms 10ms
.end
