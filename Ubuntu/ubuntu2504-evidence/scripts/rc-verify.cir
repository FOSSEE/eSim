* ngspice verification on Ubuntu 25.04 - RC transient, the same class of
* circuit eSim drives. Written as a plain SPICE deck so the simulation
* result depends only on ngspice itself.
V1 in 0 PULSE(0 5 0 1n 1n 10m 20m)
R1 in out 1k
C1 out 0 1u
.tran 0.5m 20m
.plot tran v(in) v(out)
.print tran v(out)
.end
