.title KiCad schematic
Q25 Net-_D1-Pad1_ Net-_D5-Pad1_ Net-_C3-Pad2_ eSim_NPN
U3 Net-_D7-Pad1_ Net-_Q9-Pad2_ Net-_Q15-Pad2_ Net-_C1-Pad2_ Net-_Q16-Pad2_ Net-_Q10-Pad2_ Net-_D8-Pad1_ Net-_D1-Pad1_ PORT
Q27 Net-_D5-Pad1_ Net-_C3-Pad2_ Net-_D7-Pad1_ eSim_NPN
Q21 Net-_D5-Pad1_ Net-_D1-Pad2_ Net-_D1-Pad1_ eSim_PNP
R13 Net-_C3-Pad2_ Net-_D5-Pad2_ 120
D5 Net-_D5-Pad1_ Net-_D5-Pad2_ diode
Q26 Net-_D1-Pad1_ Net-_D6-Pad1_ Net-_C4-Pad2_ eSim_NPN
R16 Net-_C4-Pad2_ Net-_D8-Pad1_ 50
Q28 Net-_D6-Pad1_ Net-_C4-Pad2_ Net-_D8-Pad1_ eSim_NPN
C5 Net-_C5-Pad1_ Net-_C3-Pad2_ 10p
D7 Net-_D7-Pad1_ Net-_D5-Pad2_ diode
R15 Net-_C3-Pad2_ Net-_D7-Pad1_ 50
Q22 Net-_D5-Pad2_ Net-_C5-Pad1_ Net-_Q17-Pad2_ eSim_NPN
Q15 Net-_C3-Pad1_ Net-_Q15-Pad2_ Net-_Q11-Pad1_ eSim_PNP
Q9 Net-_D3-Pad1_ Net-_Q9-Pad2_ Net-_Q11-Pad1_ eSim_PNP
D3 Net-_D3-Pad1_ Net-_C1-Pad1_ diode
Q13 Net-_C3-Pad1_ Net-_D3-Pad1_ Net-_Q13-Pad3_ eSim_NPN
R5 Net-_Q11-Pad3_ Net-_D1-Pad1_ 5.6k
Q11 Net-_Q11-Pad1_ Net-_D1-Pad2_ Net-_Q11-Pad3_ eSim_PNP
Q19 Net-_D5-Pad1_ Net-_C3-Pad1_ Net-_C5-Pad1_ eSim_NPN
C3 Net-_C3-Pad1_ Net-_C3-Pad2_ 5p
U1 Net-_C1-Pad2_ Net-_M1-Pad2_ zener
M1 Net-_D1-Pad1_ Net-_M1-Pad2_ Net-_C1-Pad2_ Net-_C1-Pad2_ mosfet_n
Q1 Net-_D1-Pad1_ Net-_M1-Pad2_ Net-_Q1-Pad3_ eSim_NPN
R1 Net-_C1-Pad2_ Net-_Q1-Pad3_ 10k
Q7 Net-_D1-Pad2_ Net-_M1-Pad2_ Net-_Q1-Pad3_ eSim_NPN
C1 Net-_C1-Pad1_ Net-_C1-Pad2_ 10p
U2 Net-_C1-Pad2_ Net-_M2-Pad2_ zener
Q5 Net-_D1-Pad1_ Net-_M1-Pad2_ Net-_Q1-Pad3_ eSim_NPN
Q3 Net-_D1-Pad1_ Net-_M1-Pad2_ Net-_Q1-Pad3_ eSim_NPN
C2 Net-_C2-Pad1_ Net-_C1-Pad2_ 10p
R2 Net-_C1-Pad2_ Net-_Q2-Pad3_ 10k
D1 Net-_D1-Pad1_ Net-_D1-Pad2_ diode
Q18 Net-_C4-Pad1_ Net-_Q18-Pad2_ Net-_C1-Pad2_ eSim_NPN
R11 Net-_C1-Pad2_ Net-_Q18-Pad2_ 200
R8 Net-_C1-Pad2_ Net-_Q14-Pad3_ 10k
R4 Net-_C1-Pad2_ Net-_C2-Pad1_ 4.7k
R7 Net-_C1-Pad2_ Net-_Q13-Pad3_ 10k
R3 Net-_C1-Pad2_ Net-_C1-Pad1_ 4.7k
Q17 Net-_C3-Pad1_ Net-_Q17-Pad2_ Net-_C1-Pad2_ eSim_NPN
R10 Net-_C1-Pad2_ Net-_Q17-Pad2_ 200
R9 Net-_Q17-Pad2_ Net-_C5-Pad1_ 200
R12 Net-_Q18-Pad2_ Net-_C6-Pad1_ 200
Q2 Net-_D1-Pad1_ Net-_M2-Pad2_ Net-_Q2-Pad3_ eSim_NPN
Q6 Net-_D1-Pad1_ Net-_M2-Pad2_ Net-_Q2-Pad3_ eSim_NPN
Q8 Net-_D2-Pad2_ Net-_M2-Pad2_ Net-_Q2-Pad3_ eSim_NPN
Q4 Net-_D1-Pad1_ Net-_M2-Pad2_ Net-_Q2-Pad3_ eSim_NPN
Q16 Net-_C4-Pad1_ Net-_Q16-Pad2_ Net-_Q10-Pad3_ eSim_PNP
D2 Net-_D1-Pad1_ Net-_D2-Pad2_ diode
R6 Net-_Q12-Pad3_ Net-_D1-Pad1_ 5.6k
Q12 Net-_Q10-Pad3_ Net-_D2-Pad2_ Net-_Q12-Pad3_ eSim_PNP
Q10 Net-_D4-Pad1_ Net-_Q10-Pad2_ Net-_Q10-Pad3_ eSim_PNP
Q14 Net-_C4-Pad1_ Net-_D4-Pad1_ Net-_Q14-Pad3_ eSim_NPN
D4 Net-_D4-Pad1_ Net-_C2-Pad1_ diode
Q20 Net-_D6-Pad1_ Net-_C4-Pad1_ Net-_C6-Pad1_ eSim_NPN
C4 Net-_C4-Pad1_ Net-_C4-Pad2_ 5p
C6 Net-_C6-Pad1_ Net-_C4-Pad2_ 10p
D8 Net-_D8-Pad1_ Net-_D6-Pad2_ diode
Q23 Net-_D6-Pad2_ Net-_C6-Pad1_ Net-_Q18-Pad2_ eSim_NPN
Q24 Net-_D6-Pad1_ Net-_D2-Pad2_ Net-_D1-Pad1_ eSim_PNP
R14 Net-_C4-Pad2_ Net-_D6-Pad2_ 120
D6 Net-_D6-Pad1_ Net-_D6-Pad2_ diode
M2 Net-_D1-Pad1_ Net-_M2-Pad2_ Net-_C1-Pad2_ Net-_C1-Pad2_ mosfet_n
.end
