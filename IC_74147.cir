.title KiCad schematic
U46 Net-_U38-Pad3_ Net-_U39-Pad3_ Net-_U46-Pad3_ d_or
U45 Net-_U34-Pad3_ Net-_U35-Pad3_ Net-_U45-Pad3_ d_and
U44 Net-_U32-Pad3_ Net-_U33-Pad3_ Net-_U44-Pad3_ d_and
U38 Net-_U13-Pad2_ Net-_U24-Pad3_ Net-_U38-Pad3_ d_and
U39 Net-_U14-Pad2_ Net-_U24-Pad3_ Net-_U39-Pad3_ d_and
U37 Net-_U16-Pad2_ Net-_U24-Pad3_ Net-_U37-Pad3_ d_and
U33 Net-_U22-Pad2_ Net-_U24-Pad3_ Net-_U33-Pad3_ d_and
U32 Net-_U11-Pad2_ Net-_U21-Pad2_ Net-_U32-Pad3_ d_and
U31 Net-_U17-Pad2_ Net-_U24-Pad3_ Net-_U31-Pad3_ d_and
U36 Net-_U15-Pad2_ Net-_U24-Pad3_ Net-_U36-Pad3_ d_and
U34 Net-_U22-Pad2_ Net-_U12-Pad2_ Net-_U34-Pad3_ d_and
U35 Net-_U21-Pad2_ Net-_U24-Pad3_ Net-_U35-Pad3_ d_and
U29 Net-_U14-Pad2_ Net-_U23-Pad2_ Net-_U29-Pad3_ d_and
U28 Net-_U12-Pad2_ Net-_U24-Pad3_ Net-_U28-Pad3_ d_and
U30 Net-_U16-Pad2_ Net-_U24-Pad3_ Net-_U30-Pad3_ d_and
U49 Net-_U25-Pad3_ Net-_U26-Pad3_ Net-_U49-Pad3_ d_and
U43 Net-_U27-Pad3_ Net-_U28-Pad3_ Net-_U43-Pad3_ d_and
U48 Net-_U29-Pad3_ Net-_U24-Pad3_ Net-_U48-Pad3_ d_and
U53 Net-_U49-Pad3_ Net-_U24-Pad3_ Net-_U53-Pad3_ d_and
U54 Net-_U53-Pad3_ Net-_U43-Pad3_ Net-_U54-Pad3_ d_or
U55 Net-_U48-Pad3_ Net-_U30-Pad3_ Net-_U55-Pad3_ d_or
U27 Net-_U21-Pad2_ Net-_U23-Pad2_ Net-_U27-Pad3_ d_and
U25 Net-_U19-Pad2_ Net-_U20-Pad2_ Net-_U25-Pad3_ d_and
U26 Net-_U21-Pad2_ Net-_U23-Pad2_ Net-_U26-Pad3_ d_and
U1 Net-_U1-Pad1_ Net-_U1-Pad2_ Net-_U1-Pad3_ Net-_U1-Pad4_ Net-_U1-Pad5_ Net-_U1-Pad6_ Net-_U1-Pad7_ unconnected-_U1-Pad8_ Net-_U1-Pad9_ Net-_U1-Pad10_ Net-_U1-Pad11_ Net-_U1-Pad12_ Net-_U1-Pad13_ Net-_U1-Pad14_ unconnected-_U1-Pad15_ unconnected-_U1-Pad16_ PORT
U51 Net-_U36-Pad3_ Net-_U37-Pad3_ Net-_U51-Pad3_ d_or
U50 Net-_U44-Pad3_ Net-_U45-Pad3_ Net-_U50-Pad3_ d_or
U61 Net-_U59-Pad3_ Net-_U1-Pad9_ d_inverter
U59 Net-_U58-Pad3_ Net-_U31-Pad3_ Net-_U59-Pad3_ d_or
U58 Net-_U54-Pad3_ Net-_U55-Pad3_ Net-_U58-Pad3_ d_or
U60 Net-_U57-Pad3_ Net-_U1-Pad7_ d_inverter
U57 Net-_U50-Pad3_ Net-_U51-Pad3_ Net-_U57-Pad3_ d_or
U47 Net-_U40-Pad3_ Net-_U41-Pad3_ Net-_U47-Pad3_ d_or
U42 Net-_U18-Pad2_ Net-_U17-Pad2_ Net-_U1-Pad14_ d_nor
U56 Net-_U52-Pad3_ Net-_U1-Pad6_ d_inverter
U52 Net-_U46-Pad3_ Net-_U47-Pad3_ Net-_U52-Pad3_ d_or
U40 Net-_U15-Pad2_ Net-_U24-Pad3_ Net-_U40-Pad3_ d_and
U41 Net-_U16-Pad2_ Net-_U24-Pad3_ Net-_U41-Pad3_ d_and
U9 Net-_U1-Pad5_ Net-_U18-Pad1_ d_inverter
U8 Net-_U1-Pad10_ Net-_U17-Pad1_ d_inverter
U18 Net-_U18-Pad1_ Net-_U18-Pad2_ d_buffer
U17 Net-_U17-Pad1_ Net-_U17-Pad2_ d_buffer
U24 Net-_U18-Pad2_ Net-_U17-Pad2_ Net-_U24-Pad3_ d_nor
U5 Net-_U1-Pad3_ Net-_U15-Pad1_ d_inverter
U7 Net-_U1-Pad4_ Net-_U16-Pad1_ d_inverter
U4 Net-_U1-Pad2_ Net-_U14-Pad1_ d_inverter
U3 Net-_U1-Pad1_ Net-_U13-Pad1_ d_inverter
U15 Net-_U15-Pad1_ Net-_U15-Pad2_ d_buffer
U16 Net-_U16-Pad1_ Net-_U16-Pad2_ d_buffer
U14 Net-_U14-Pad1_ Net-_U14-Pad2_ d_buffer
U22 Net-_U14-Pad2_ Net-_U22-Pad2_ d_inverter
U23 Net-_U15-Pad2_ Net-_U23-Pad2_ d_inverter
U21 Net-_U13-Pad2_ Net-_U21-Pad2_ d_inverter
U13 Net-_U13-Pad1_ Net-_U13-Pad2_ d_buffer
U12 Net-_U12-Pad1_ Net-_U12-Pad2_ d_buffer
U20 Net-_U11-Pad2_ Net-_U20-Pad2_ d_inverter
U19 Net-_U10-Pad2_ Net-_U19-Pad2_ d_buffer
U11 Net-_U11-Pad1_ Net-_U11-Pad2_ d_buffer
U10 Net-_U1-Pad11_ Net-_U10-Pad2_ d_inverter
U6 Net-_U1-Pad13_ Net-_U12-Pad1_ d_inverter
U2 Net-_U1-Pad12_ Net-_U11-Pad1_ d_inverter
.end
