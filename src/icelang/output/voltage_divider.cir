* voltage_divider

V1 vin gnd 9V
R1 vin mid 10k
R2 mid gnd 10k

* test source auto-generated for port vin
V_test vin gnd PULSE(0 5 0 1n 1n 500u 1m)

.tran 1us 10ms
.end
