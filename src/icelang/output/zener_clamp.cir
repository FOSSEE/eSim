* zener_clamp

R1 vin mid 1k
Z1 mid gnd 5V

* test source auto-generated for port vin
V_test vin gnd PULSE(0 5 0 1n 1n 500u 1m)

.tran 1us 10ms
.end
