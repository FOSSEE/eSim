.title KiCad schematic
Q3 Net-_Q1-Pad2_ Net-_C2-Pad1_ Net-_C1-Pad1_ eSim_PNP
R1 Net-_C1-Pad1_ Net-_Q2-Pad1_ 50
Q1 Net-_C1-Pad1_ Net-_Q1-Pad2_ Net-_Q1-Pad3_ eSim_NPN
Q2 Net-_Q2-Pad1_ Net-_Q2-Pad1_ Net-_C1-Pad1_ eSim_NPN
R2 Net-_C1-Pad2_ Net-_Q1-Pad2_ 2k
C1 Net-_C1-Pad1_ Net-_C1-Pad2_ 15p
U2 b plot_v1
Q5 Net-_C2-Pad1_ Net-_Q5-Pad2_ Net-_Q5-Pad3_ eSim_PNP
U4 Net-_Q2-Pad1_ Net-_Q1-Pad3_ PORT
R7 Net-_Q1-Pad3_ c 2.6k
U3 c plot_v1
Q6 Net-_Q5-Pad2_ b c eSim_NPN
R6 Net-_Q5-Pad3_ Net-_Q2-Pad1_ 1k
Q7 Net-_Q5-Pad2_ Net-_Q5-Pad2_ Net-_Q2-Pad1_ eSim_PNP
R5 Net-_Q1-Pad3_ b 2k
R3 Net-_Q1-Pad3_ Net-_Q1-Pad2_ 30k
Q4 Net-_C2-Pad1_ Net-_C2-Pad2_ Net-_Q1-Pad3_ eSim_NPN
R4 Net-_C2-Pad2_ b 10k
C2 Net-_C2-Pad1_ Net-_C2-Pad2_ 30p
IU1 b Net-_Q2-Pad1_ dc 7
.end
