.title KiCad schematic
R3 Net-_R3-Pad1_ Net-_R3-Pad2_ 51
U2 out1 plot_v1
R4 out2 out1 2k
U3 out2 plot_v1
U4 in1 plot_v1
R5 Net-_R3-Pad2_ in1 12k
v4 GND in1 sine
v3 Net-_X1-Pad10_ GND DC
U1 in2 plot_v1
v1 in2 GND sine
R1 Net-_R1-Pad1_ in2 12k
v2 Net-_X1-Pad5_ GND DC
R2 Net-_R2-Pad1_ Net-_R1-Pad1_ 51
X1 Net-_R2-Pad1_ unconnected-_X1-Pad2_ unconnected-_X1-Pad3_ unconnected-_X1-Pad4_ Net-_X1-Pad5_ unconnected-_X1-Pad6_ out1 out2 unconnected-_X1-Pad9_ Net-_X1-Pad10_ unconnected-_X1-Pad11_ unconnected-_X1-Pad12_ unconnected-_X1-Pad13_ Net-_R3-Pad1_ IC_NE592
.end
