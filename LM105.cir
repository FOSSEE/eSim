.title KiCad schematic
Q16 Net-_Q10-Pad3_ Net-_C2-Pad2_ Net-_Q12-Pad3_ eSim_NPN
Q12 Net-_C1-Pad1_ unconnected-_Q12-Pad2_ Net-_Q12-Pad3_ eSim_NPN
R5 GND Net-_Q12-Pad3_ 2.2k
C1 Net-_C1-Pad1_ GND 5p
Q10 Net-_Q10-Pad1_ Net-_Q10-Pad2_ Net-_Q10-Pad3_ eSim_NPN
Q19 Net-_C2-Pad1_ Net-_C2-Pad2_ unconnected-_Q12-Pad2_ eSim_NPN
Q14 Net-_C2-Pad1_ Net-_C1-Pad1_ Net-_Q10-Pad3_ eSim_NPN
C4 output GND 1u
Q21 Net-_Q20-Pad3_ Net-_Q20-Pad1_ input eSim_PNP
U2 input plot_v1
v1 input GND DC
R9 Net-_Q20-Pad3_ output 0.65
U3 output plot_v1
Q17 input Net-_Q15-Pad1_ Net-_Q17-Pad3_ eSim_NPN
R6 Net-_Q18-Pad2_ Net-_Q17-Pad3_ 1.86k
U6 input plot_v1
R8 input Net-_Q20-Pad1_ 600
Q20 Net-_Q20-Pad1_ Net-_Q17-Pad3_ Net-_Q20-Pad3_ eSim_NPN
Q9 input Net-_Q3-Pad1_ Net-_Q11-Pad1_ eSim_NPN
Q18 Net-_Q15-Pad1_ Net-_Q18-Pad2_ output eSim_NPN
Q8 Net-_Q11-Pad1_ Net-_Q11-Pad2_ Net-_Q6-Pad3_ eSim_NPN
Q6 Net-_Q13-Pad2_ Net-_Q13-Pad2_ Net-_Q6-Pad3_ eSim_NPN
Q15 Net-_Q15-Pad1_ Net-_Q15-Pad1_ Net-_C2-Pad1_ eSim_NPN
Q11 Net-_Q11-Pad1_ Net-_Q11-Pad2_ Net-_Q10-Pad1_ eSim_NPN
R4 Net-_C1-Pad1_ Net-_Q13-Pad3_ 4.4k
Q13 Net-_M1-Pad1_ Net-_Q13-Pad2_ Net-_Q13-Pad3_ eSim_NPN
R10 output Net-_C2-Pad2_ 5.5k
R11 Net-_C2-Pad2_ GND 3.15k
C3 input GND 0.01u
C2 Net-_C2-Pad1_ Net-_C2-Pad2_ 47p
R7 Net-_Q20-Pad3_ Net-_Q18-Pad2_ 1.32k
U1 GND Net-_Q4-Pad1_ zener
Q5 Net-_Q3-Pad1_ Net-_Q4-Pad1_ Net-_Q13-Pad2_ eSim_NPN
Q3 Net-_Q3-Pad1_ Net-_Q1-Pad1_ input eSim_PNP
Q4 Net-_Q4-Pad1_ Net-_Q1-Pad1_ input eSim_PNP
Q1 Net-_Q1-Pad1_ Net-_Q1-Pad1_ Net-_M1-Pad1_ eSim_NPN
Q2 Net-_Q15-Pad1_ Net-_Q1-Pad1_ input eSim_PNP
R12 Net-_Q1-Pad1_ Net-_Q3-Pad1_ 2.8k
M1 Net-_M1-Pad1_ GND GND GND mosfet_n
R2 unconnected-_Q12-Pad2_ Net-_Q10-Pad2_ 6.8k
R1 Net-_Q10-Pad2_ Net-_Q6-Pad3_ 3k
R3 Net-_Q7-Pad1_ unconnected-_Q12-Pad2_ 2.85k
Q7 Net-_Q7-Pad1_ Net-_Q7-Pad1_ GND eSim_NPN
.end
