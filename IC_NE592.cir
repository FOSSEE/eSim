.title KiCad schematic
Q5 Net-_Q10-Pad2_ Net-_Q10-Pad2_ Net-_Q5-Pad3_ eSim_NPN
R8 Net-_R10-Pad1_ Net-_Q5-Pad3_ 1.4k
U1 Net-_Q3-Pad2_ unconnected-_U1-Pad2_ Net-_Q4-Pad1_ Net-_Q3-Pad3_ Net-_R10-Pad1_ unconnected-_U1-Pad6_ Net-_Q11-Pad3_ Net-_Q10-Pad1_ unconnected-_U1-Pad9_ Net-_Q11-Pad1_ Net-_Q2-Pad1_ Net-_Q1-Pad3_ unconnected-_U1-Pad13_ Net-_Q1-Pad2_ PORT
Q4 Net-_Q4-Pad1_ Net-_Q10-Pad2_ Net-_Q4-Pad3_ eSim_NPN
R6 Net-_R10-Pad1_ Net-_Q4-Pad3_ 300
R3 Net-_R10-Pad1_ Net-_Q2-Pad3_ 300
Q2 Net-_Q2-Pad1_ Net-_Q10-Pad2_ Net-_Q2-Pad3_ eSim_NPN
R15 Net-_R10-Pad1_ Net-_Q12-Pad3_ 400
Q7 Net-_Q6-Pad3_ Net-_Q10-Pad2_ Net-_Q7-Pad3_ eSim_NPN
R10 Net-_R10-Pad1_ Net-_Q7-Pad3_ 250
Q12 Net-_Q11-Pad3_ Net-_Q10-Pad2_ Net-_Q12-Pad3_ eSim_NPN
Q10 Net-_Q10-Pad1_ Net-_Q10-Pad2_ Net-_Q10-Pad3_ eSim_NPN
R14 Net-_R10-Pad1_ Net-_Q10-Pad3_ 400
R13 Net-_Q11-Pad3_ Net-_Q3-Pad1_ 7k
Q3 Net-_Q3-Pad1_ Net-_Q3-Pad2_ Net-_Q3-Pad3_ eSim_NPN
R1 Net-_Q1-Pad1_ Net-_Q11-Pad1_ 2.4k
R4 Net-_Q3-Pad1_ Net-_Q11-Pad1_ 2.4k
R7 Net-_Q10-Pad2_ Net-_Q11-Pad1_ 10k
Q1 Net-_Q1-Pad1_ Net-_Q1-Pad2_ Net-_Q1-Pad3_ eSim_NPN
R5 Net-_Q4-Pad1_ Net-_Q3-Pad3_ 80
R2 Net-_Q2-Pad1_ Net-_Q1-Pad3_ 50
R11 Net-_Q8-Pad1_ Net-_Q11-Pad1_ 0.7k
R9 Net-_Q11-Pad2_ Net-_Q11-Pad1_ 0.7k
Q6 Net-_Q11-Pad2_ Net-_Q3-Pad1_ Net-_Q6-Pad3_ eSim_NPN
Q8 Net-_Q8-Pad1_ Net-_Q1-Pad1_ Net-_Q6-Pad3_ eSim_NPN
R12 Net-_Q10-Pad1_ Net-_Q1-Pad1_ 7k
Q9 Net-_Q11-Pad1_ Net-_Q8-Pad1_ Net-_Q10-Pad1_ eSim_NPN
Q11 Net-_Q11-Pad1_ Net-_Q11-Pad2_ Net-_Q11-Pad3_ eSim_NPN
.end
