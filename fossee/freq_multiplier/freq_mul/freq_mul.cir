* C:\Users\VLSI\eSim-Workspace\freq_mul\freq_mul.cir

* EESchema Netlist Version 1.1 (Spice format) creation date: 03/03/2026 20:29:28

* To exclude a component from the Spice Netlist add [Spice_Netlist_Enabled] user FIELD set to: N
* To reorder the component spice node sequence add [Spice_Node_Sequence] user FIELD and define sequence: 2,1,0

* Sheet Name: /
U2  Net-_U2-Pad1_ Net-_U2-Pad2_ Net-_U2-Pad3_ freq_mul
U4  clkout rst0 Net-_U2-Pad1_ Net-_U2-Pad2_ adc_bridge_2
v1  clkout GND pulse
v2  rst0 GND pulse
U5  Net-_U2-Pad3_ clkin dac_bridge_1
U1  clkout plot_v1
U3  rst0 plot_v1
U6  clkin plot_v1

.end
