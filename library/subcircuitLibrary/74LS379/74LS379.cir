.title KiCad schematic
U9 Net-_U1-Pad5_ Net-_U10-Pad2_ Net-_U10-Pad3_ unconnected-_U9-Pad4_ Net-_U1-Pad6_ Net-_U1-Pad7_ d_dff
U1 Net-_U1-Pad1_ Net-_U1-Pad2_ Net-_U1-Pad3_ Net-_U1-Pad4_ Net-_U1-Pad5_ Net-_U1-Pad6_ Net-_U1-Pad7_ unconnected-_U1-Pad8_ Net-_U1-Pad9_ Net-_U1-Pad10_ Net-_U1-Pad11_ Net-_U1-Pad12_ Net-_U1-Pad13_ Net-_U1-Pad14_ Net-_U1-Pad15_ unconnected-_U1-Pad16_ PORT
U11 Net-_U1-Pad13_ Net-_U10-Pad2_ Net-_U10-Pad3_ unconnected-_U11-Pad4_ Net-_U1-Pad14_ Net-_U1-Pad15_ d_dff
U10 Net-_U1-Pad12_ Net-_U10-Pad2_ Net-_U10-Pad3_ unconnected-_U10-Pad4_ Net-_U1-Pad11_ Net-_U1-Pad10_ d_dff
U3 Net-_U1-Pad9_ Net-_U10-Pad2_ d_inverter
U2 Net-_U1-Pad1_ Net-_U2-Pad2_ d_inverter
U4 Net-_U4-Pad1_ Net-_U10-Pad3_ d_inverter
U7 Net-_U5-Pad1_ Net-_U2-Pad2_ Net-_U10-Pad3_ d_and
U6 Net-_U10-Pad2_ Net-_U4-Pad1_ Net-_U5-Pad2_ d_and
U5 Net-_U5-Pad1_ Net-_U5-Pad2_ d_inverter
U8 Net-_U1-Pad4_ Net-_U10-Pad2_ Net-_U10-Pad3_ unconnected-_U8-Pad4_ Net-_U1-Pad3_ Net-_U1-Pad2_ d_dff
.end
