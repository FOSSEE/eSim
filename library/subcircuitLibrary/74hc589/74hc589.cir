.title KiCad schematic
U14 Net-_U1-Pad4_ Net-_U10-Pad2_ Net-_U14-Pad3_ unconnected-_U14-Pad4_ Net-_U14-Pad5_ unconnected-_U14-Pad6_ d_dff
U1 Net-_U1-Pad1_ Net-_U1-Pad2_ Net-_U1-Pad3_ Net-_U1-Pad4_ Net-_U1-Pad5_ Net-_U1-Pad6_ Net-_U1-Pad7_ unconnected-_U1-Pad8_ Net-_U1-Pad9_ Net-_U1-Pad10_ Net-_U1-Pad11_ Net-_U1-Pad12_ Net-_U1-Pad13_ Net-_U1-Pad14_ Net-_U1-Pad15_ Net-_U14-Pad3_ PORT
U26 Net-_U14-Pad5_ Net-_U26-Pad2_ d_inverter
U27 Net-_U19-Pad1_ Net-_U27-Pad2_ d_inverter
U15 Net-_U1-Pad5_ Net-_U10-Pad2_ Net-_U14-Pad3_ unconnected-_U15-Pad4_ Net-_U15-Pad5_ unconnected-_U15-Pad6_ d_dff
U29 Net-_U19-Pad1_ Net-_U29-Pad2_ d_inverter
U28 Net-_U15-Pad5_ Net-_U28-Pad2_ d_inverter
U45 Net-_U28-Pad2_ Net-_U29-Pad2_ Net-_U45-Pad3_ d_nand
U46 Net-_U19-Pad1_ Net-_U16-Pad5_ Net-_U46-Pad3_ d_nand
U30 Net-_U16-Pad5_ Net-_U30-Pad2_ d_inverter
U53 Net-_U52-Pad5_ Net-_U50-Pad2_ Net-_U40-Pad3_ Net-_U41-Pad3_ Net-_U53-Pad5_ unconnected-_U53-Pad6_ d_dlatch
U13 Net-_U1-Pad3_ Net-_U10-Pad2_ Net-_U14-Pad3_ unconnected-_U13-Pad4_ Net-_U13-Pad5_ unconnected-_U13-Pad6_ d_dff
U63 Net-_U61-Pad3_ Net-_U62-Pad3_ Net-_U1-Pad9_ d_or
U59 Net-_U58-Pad1_ Net-_U59-Pad2_ d_inverter
U58 Net-_U58-Pad1_ Net-_U58-Pad2_ d_inverter
U60 Net-_U57-Pad5_ Net-_U60-Pad2_ d_inverter
U62 Net-_U60-Pad2_ Net-_U58-Pad2_ Net-_U62-Pad3_ d_and
U61 Net-_U59-Pad2_ Net-_U57-Pad5_ Net-_U61-Pad3_ d_nand
U57 Net-_U56-Pad5_ Net-_U50-Pad2_ Net-_U48-Pad3_ Net-_U49-Pad3_ Net-_U57-Pad5_ unconnected-_U57-Pad6_ d_dlatch
U31 Net-_U19-Pad1_ Net-_U31-Pad2_ d_inverter
U16 Net-_U1-Pad6_ Net-_U10-Pad2_ Net-_U14-Pad3_ unconnected-_U16-Pad4_ Net-_U16-Pad5_ unconnected-_U16-Pad6_ d_dff
U17 Net-_U1-Pad7_ Net-_U10-Pad2_ Net-_U14-Pad3_ unconnected-_U17-Pad4_ Net-_U17-Pad5_ unconnected-_U17-Pad6_ d_dff
U48 Net-_U19-Pad1_ Net-_U17-Pad5_ Net-_U48-Pad3_ d_nand
U33 Net-_U19-Pad1_ Net-_U33-Pad2_ d_inverter
U49 Net-_U32-Pad2_ Net-_U33-Pad2_ Net-_U49-Pad3_ d_nand
U32 Net-_U17-Pad5_ Net-_U32-Pad2_ d_inverter
U47 Net-_U30-Pad2_ Net-_U31-Pad2_ Net-_U47-Pad3_ d_nand
U54 Net-_U53-Pad5_ Net-_U50-Pad2_ Net-_U42-Pad3_ Net-_U43-Pad3_ Net-_U54-Pad5_ unconnected-_U54-Pad6_ d_dlatch
U56 Net-_U55-Pad5_ Net-_U50-Pad2_ Net-_U46-Pad3_ Net-_U47-Pad3_ Net-_U56-Pad5_ unconnected-_U56-Pad6_ d_dlatch
U42 Net-_U19-Pad1_ Net-_U14-Pad5_ Net-_U42-Pad3_ d_nand
U55 Net-_U54-Pad5_ Net-_U50-Pad2_ Net-_U44-Pad3_ Net-_U45-Pad3_ Net-_U55-Pad5_ unconnected-_U55-Pad6_ d_dlatch
U43 Net-_U26-Pad2_ Net-_U27-Pad2_ Net-_U43-Pad3_ d_nand
U44 Net-_U19-Pad1_ Net-_U15-Pad5_ Net-_U44-Pad3_ d_nand
U36 Net-_U19-Pad1_ Net-_U11-Pad5_ Net-_U36-Pad3_ d_nand
U37 Net-_U20-Pad2_ Net-_U21-Pad2_ Net-_U37-Pad3_ d_nand
U21 Net-_U19-Pad1_ Net-_U21-Pad2_ d_inverter
U20 Net-_U11-Pad5_ Net-_U20-Pad2_ d_inverter
U51 Net-_U50-Pad5_ Net-_U50-Pad2_ Net-_U36-Pad3_ Net-_U37-Pad3_ Net-_U51-Pad5_ unconnected-_U51-Pad6_ d_dlatch
U19 Net-_U19-Pad1_ Net-_U19-Pad2_ d_inverter
U18 Net-_U10-Pad5_ Net-_U18-Pad2_ d_inverter
U35 Net-_U18-Pad2_ Net-_U19-Pad2_ Net-_U35-Pad3_ d_nand
U34 Net-_U19-Pad1_ Net-_U10-Pad5_ Net-_U34-Pad3_ d_nand
U50 Net-_U1-Pad14_ Net-_U50-Pad2_ Net-_U34-Pad3_ Net-_U35-Pad3_ Net-_U50-Pad5_ unconnected-_U50-Pad6_ d_dlatch
U52 Net-_U51-Pad5_ Net-_U50-Pad2_ Net-_U38-Pad3_ Net-_U39-Pad3_ Net-_U52-Pad5_ unconnected-_U52-Pad6_ d_dlatch
U11 Net-_U1-Pad1_ Net-_U10-Pad2_ Net-_U14-Pad3_ unconnected-_U11-Pad4_ Net-_U11-Pad5_ unconnected-_U11-Pad6_ d_dff
U25 Net-_U19-Pad1_ Net-_U25-Pad2_ d_inverter
U12 Net-_U1-Pad2_ Net-_U10-Pad2_ Net-_U14-Pad3_ unconnected-_U12-Pad4_ Net-_U12-Pad5_ unconnected-_U12-Pad6_ d_dff
U6 Net-_U2-Pad2_ Net-_U6-Pad2_ d_buffer
U2 Net-_U1-Pad10_ Net-_U2-Pad2_ d_inverter
U9 Net-_U6-Pad2_ Net-_U58-Pad1_ d_inverter
U7 Net-_U3-Pad2_ Net-_U50-Pad2_ d_buffer
U8 Net-_U5-Pad2_ Net-_U10-Pad2_ d_buffer
U10 Net-_U1-Pad15_ Net-_U10-Pad2_ Net-_U14-Pad3_ unconnected-_U10-Pad4_ Net-_U10-Pad5_ unconnected-_U10-Pad6_ d_dff
U3 Net-_U1-Pad11_ Net-_U3-Pad2_ d_inverter
U4 Net-_U1-Pad13_ Net-_U19-Pad1_ d_inverter
U5 Net-_U1-Pad12_ Net-_U5-Pad2_ d_inverter
U41 Net-_U24-Pad2_ Net-_U25-Pad2_ Net-_U41-Pad3_ d_nand
U40 Net-_U19-Pad1_ Net-_U13-Pad5_ Net-_U40-Pad3_ d_nand
U24 Net-_U13-Pad5_ Net-_U24-Pad2_ d_inverter
U38 Net-_U19-Pad1_ Net-_U12-Pad5_ Net-_U38-Pad3_ d_nand
U23 Net-_U19-Pad1_ Net-_U23-Pad2_ d_inverter
U22 Net-_U12-Pad5_ Net-_U22-Pad2_ d_inverter
U39 Net-_U22-Pad2_ Net-_U23-Pad2_ Net-_U39-Pad3_ d_nand
.end
