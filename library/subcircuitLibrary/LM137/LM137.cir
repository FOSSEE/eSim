.title KiCad schematic
R22 Net-_C3-Pad1_ Net-_D5-Pad2_ 2k
R23 Net-_Q29-Pad3_ Net-_C3-Pad1_ 20k
D5 Net-_C4-Pad2_ Net-_D5-Pad2_ eSim_Diode
C3 Net-_C3-Pad1_ Net-_C1-Pad2_ 15p
C1 Net-_C1-Pad1_ Net-_C1-Pad2_ 15p
R19 Net-_Q21-Pad1_ Net-_C1-Pad1_ 5k
R25 Net-_C1-Pad2_ Net-_Q32-Pad2_ 2k
Q29 Net-_Q28-Pad1_ Net-_C4-Pad2_ Net-_Q29-Pad3_ eSim_PNP
R34 Net-_D5-Pad2_ Net-_R34-Pad2_ 60
U1 Net-_R34-Pad2_ Net-_C4-Pad2_ Net-_Q13-Pad3_ PORT
Q26 Net-_Q26-Pad1_ Net-_Q16-Pad2_ Net-_Q26-Pad3_ eSim_NPN
R21 Net-_Q26-Pad3_ Net-_Q13-Pad3_ 500
Q30 Net-_C5-Pad1_ Net-_C5-Pad2_ Net-_D3-Pad1_ eSim_NPN
R18 Net-_Q24-Pad3_ Net-_Q13-Pad3_ 2.4k
Q31 Net-_C5-Pad1_ Net-_C5-Pad2_ Net-_Q31-Pad3_ eSim_NPN
R29 Net-_D3-Pad1_ Net-_Q31-Pad3_ 150
R32 Net-_Q31-Pad3_ Net-_R32-Pad2_ 10
R33 Net-_Q33-Pad3_ Net-_Q35-Pad3_ 250
C5 Net-_C5-Pad1_ Net-_C5-Pad2_ 2p
R31 Net-_R26-Pad2_ Net-_C5-Pad2_ 12k
R36 Net-_Q35-Pad3_ Net-_R32-Pad2_ 0.2
R37 Net-_R32-Pad2_ Net-_Q13-Pad3_ 0.04
Q28 Net-_Q28-Pad1_ Net-_Q21-Pad1_ Net-_D4-Pad2_ eSim_NPN
Q24 Net-_Q15-Pad1_ Net-_Q16-Pad2_ Net-_Q24-Pad3_ eSim_NPN
R24 Net-_C2-Pad2_ Net-_C5-Pad1_ 15k
R26 Net-_Q15-Pad1_ Net-_R26-Pad2_ 12k
Q27 Net-_Q26-Pad3_ Net-_C2-Pad1_ Net-_Q15-Pad1_ eSim_PNP
R27 Net-_R26-Pad2_ Net-_C5-Pad1_ 390
C2 Net-_C2-Pad1_ Net-_C2-Pad2_ 5p
Q25 Net-_C2-Pad1_ Net-_C2-Pad2_ Net-_Q13-Pad3_ eSim_NPN
Q21 Net-_Q21-Pad1_ Net-_Q18-Pad1_ Net-_D4-Pad2_ eSim_NPN
R20 Net-_Q15-Pad1_ Net-_C2-Pad1_ 6.8k
Q35 Net-_C4-Pad2_ Net-_Q33-Pad3_ Net-_Q35-Pad3_ eSim_NPN
R35 Net-_Q34-Pad3_ Net-_C4-Pad2_ 220
Q33 Net-_C4-Pad2_ Net-_Q33-Pad2_ Net-_Q33-Pad3_ eSim_NPN
R30 Net-_Q15-Pad1_ Net-_Q33-Pad2_ 100
Q34 Net-_Q15-Pad1_ Net-_Q26-Pad1_ Net-_Q34-Pad3_ eSim_PNP
Q32 Net-_C4-Pad2_ Net-_Q32-Pad2_ Net-_Q26-Pad1_ eSim_NPN
C4 Net-_C4-Pad1_ Net-_C4-Pad2_ 25p
R28 Net-_Q32-Pad2_ Net-_C4-Pad1_ 800
Q17 Net-_D5-Pad2_ Net-_Q17-Pad2_ Net-_Q17-Pad3_ eSim_NPN
Q18 Net-_Q18-Pad1_ Net-_Q18-Pad2_ Net-_Q17-Pad3_ eSim_PNP
Q23 Net-_D5-Pad2_ Net-_C3-Pad1_ Net-_Q22-Pad3_ eSim_NPN
Q22 Net-_Q21-Pad1_ Net-_Q18-Pad2_ Net-_Q22-Pad3_ eSim_PNP
R16 Net-_D5-Pad2_ Net-_Q17-Pad2_ 2k
R1 Net-_Q13-Pad3_ Net-_Q4-Pad3_ 600
R8 Net-_R12-Pad1_ Net-_Q12-Pad1_ 8k
R7 Net-_Q13-Pad3_ Net-_Q9-Pad3_ 4.2k
R9 Net-_Q13-Pad3_ Net-_R12-Pad1_ 4k
Q13 Net-_Q10-Pad1_ Net-_Q12-Pad1_ Net-_Q13-Pad3_ eSim_NPN
Q12 Net-_Q12-Pad1_ Net-_Q12-Pad2_ Net-_Q12-Pad3_ eSim_PNP
Q9 Net-_Q12-Pad2_ Net-_Q5-Pad1_ Net-_Q9-Pad3_ eSim_NPN
R10 Net-_D1-Pad2_ Net-_Q10-Pad2_ 60k
Q8 Net-_Q12-Pad3_ Net-_Q10-Pad2_ Net-_D1-Pad1_ eSim_PNP
Q10 Net-_Q10-Pad1_ Net-_Q10-Pad2_ Net-_D1-Pad1_ eSim_PNP
Q11 Net-_Q11-Pad1_ Net-_Q10-Pad2_ Net-_D1-Pad1_ eSim_PNP
Q16 Net-_D4-Pad2_ Net-_Q16-Pad2_ Net-_Q16-Pad3_ eSim_NPN
Q20 Net-_Q18-Pad2_ Net-_Q16-Pad2_ Net-_Q20-Pad3_ eSim_NPN
R17 Net-_Q16-Pad3_ Net-_Q20-Pad3_ 6k
R15 Net-_Q16-Pad3_ Net-_Q13-Pad3_ 500
Q6 Net-_Q13-Pad3_ Net-_Q5-Pad1_ Net-_Q12-Pad3_ eSim_PNP
Q4 Net-_Q1-Pad1_ Net-_Q4-Pad2_ Net-_Q4-Pad3_ eSim_NPN
Q5 Net-_Q5-Pad1_ Net-_Q4-Pad2_ Net-_Q13-Pad3_ eSim_NPN
R6 Net-_Q12-Pad2_ Net-_Q12-Pad3_ 12k
R4 Net-_Q4-Pad2_ Net-_Q16-Pad2_ 1k
R5 Net-_Q5-Pad1_ Net-_Q4-Pad2_ 270
D1 Net-_D1-Pad1_ Net-_D1-Pad2_ eSim_Diode
R11 Net-_D2-Pad1_ Net-_D1-Pad2_ 100k
R12 Net-_R12-Pad1_ Net-_Q11-Pad1_ 20k
Q14 Net-_Q11-Pad1_ Net-_Q10-Pad1_ Net-_Q13-Pad3_ eSim_NPN
Q19 Net-_Q18-Pad1_ Net-_Q18-Pad1_ Net-_D4-Pad2_ eSim_NPN
D4 Net-_D1-Pad1_ Net-_D4-Pad2_ eSim_Diode
D3 Net-_D3-Pad1_ Net-_D3-Pad2_ eSim_Diode
R14 Net-_D3-Pad2_ Net-_D3-Pad1_ 100k
Q15 Net-_Q15-Pad1_ Net-_Q11-Pad1_ Net-_Q13-Pad3_ eSim_NPN
R13 Net-_D2-Pad1_ Net-_D3-Pad2_ 18k
D2 Net-_D2-Pad1_ Net-_D1-Pad1_ eSim_Diode
R3 Net-_Q16-Pad2_ Net-_Q3-Pad2_ 4k
R2 Net-_Q10-Pad2_ Net-_Q1-Pad2_ 750
Q3 Net-_Q10-Pad2_ Net-_Q3-Pad2_ Net-_Q1-Pad1_ eSim_NPN
Q7 Net-_Q3-Pad2_ Net-_Q10-Pad2_ Net-_D1-Pad1_ eSim_PNP
Q1 Net-_Q1-Pad1_ Net-_Q1-Pad2_ Net-_D1-Pad1_ eSim_PNP
Q2 Net-_Q10-Pad2_ Net-_Q1-Pad2_ Net-_D1-Pad1_ eSim_PNP
.end
