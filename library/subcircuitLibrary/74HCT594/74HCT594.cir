.title KiCad schematic
U24 Net-_U23-Pad5_ Net-_U1-Pad5_ d_buffer
U20 Net-_U19-Pad5_ Net-_U11-Pad2_ unconnected-_U20-Pad3_ Net-_U11-Pad4_ Net-_U20-Pad5_ unconnected-_U20-Pad6_ d_dlatch
U23 Net-_U22-Pad5_ Net-_U11-Pad2_ unconnected-_U23-Pad3_ Net-_U11-Pad4_ Net-_U23-Pad5_ unconnected-_U23-Pad6_ d_dlatch
U1 Net-_U1-Pad1_ Net-_U1-Pad2_ Net-_U1-Pad3_ Net-_U1-Pad4_ Net-_U1-Pad5_ Net-_U1-Pad6_ Net-_U1-Pad7_ unconnected-_U1-Pad8_ Net-_U1-Pad9_ Net-_U1-Pad10_ Net-_U1-Pad11_ Net-_U1-Pad12_ Net-_U1-Pad13_ Net-_U1-Pad14_ Net-_U1-Pad15_ unconnected-_U1-Pad16_ PORT
U18 Net-_U17-Pad5_ Net-_U1-Pad3_ d_buffer
U21 Net-_U20-Pad5_ Net-_U1-Pad4_ d_buffer
U15 Net-_U14-Pad5_ Net-_U1-Pad2_ d_buffer
U17 Net-_U16-Pad5_ Net-_U11-Pad2_ unconnected-_U17-Pad3_ Net-_U11-Pad4_ Net-_U17-Pad5_ unconnected-_U17-Pad6_ d_dlatch
U14 Net-_U13-Pad5_ Net-_U11-Pad2_ unconnected-_U14-Pad3_ Net-_U11-Pad4_ Net-_U14-Pad5_ unconnected-_U14-Pad6_ d_dlatch
U16 Net-_U13-Pad5_ Net-_U10-Pad2_ unconnected-_U16-Pad3_ Net-_U10-Pad4_ Net-_U16-Pad5_ unconnected-_U16-Pad6_ d_dff
U13 Net-_U10-Pad5_ Net-_U10-Pad2_ unconnected-_U13-Pad3_ Net-_U10-Pad4_ Net-_U13-Pad5_ unconnected-_U13-Pad6_ d_dff
U11 Net-_U10-Pad5_ Net-_U11-Pad2_ unconnected-_U11-Pad3_ Net-_U11-Pad4_ Net-_U11-Pad5_ unconnected-_U11-Pad6_ d_dlatch
U9 Net-_U8-Pad5_ Net-_U1-Pad15_ d_buffer
U12 Net-_U11-Pad5_ Net-_U1-Pad1_ d_buffer
U6 Net-_U1-Pad12_ Net-_U11-Pad2_ d_buffer
U3 Net-_U1-Pad13_ Net-_U11-Pad4_ d_inverter
U8 Net-_U10-Pad1_ Net-_U11-Pad2_ unconnected-_U8-Pad3_ Net-_U11-Pad4_ Net-_U8-Pad5_ unconnected-_U8-Pad6_ d_dlatch
U25 Net-_U22-Pad5_ Net-_U10-Pad2_ unconnected-_U25-Pad3_ Net-_U10-Pad4_ Net-_U25-Pad5_ unconnected-_U25-Pad6_ d_dff
U19 Net-_U16-Pad5_ Net-_U10-Pad2_ unconnected-_U19-Pad3_ Net-_U10-Pad4_ Net-_U19-Pad5_ unconnected-_U19-Pad6_ d_dff
U22 Net-_U19-Pad5_ Net-_U10-Pad2_ unconnected-_U22-Pad3_ Net-_U10-Pad4_ Net-_U22-Pad5_ unconnected-_U22-Pad6_ d_dff
U28 Net-_U25-Pad5_ Net-_U10-Pad2_ unconnected-_U28-Pad3_ Net-_U10-Pad4_ Net-_U28-Pad5_ unconnected-_U28-Pad6_ d_dff
U31 Net-_U28-Pad5_ Net-_U1-Pad9_ d_buffer
U26 Net-_U25-Pad5_ Net-_U11-Pad2_ unconnected-_U26-Pad3_ Net-_U11-Pad4_ Net-_U26-Pad5_ unconnected-_U26-Pad6_ d_dlatch
U29 Net-_U28-Pad5_ Net-_U11-Pad2_ unconnected-_U29-Pad3_ Net-_U11-Pad4_ Net-_U29-Pad5_ unconnected-_U29-Pad6_ d_dlatch
U30 Net-_U29-Pad5_ Net-_U1-Pad7_ d_buffer
U27 Net-_U26-Pad5_ Net-_U1-Pad6_ d_buffer
U7 Net-_U4-Pad2_ Net-_U10-Pad2_ unconnected-_U7-Pad3_ Net-_U10-Pad4_ Net-_U10-Pad1_ unconnected-_U7-Pad6_ d_dff
U4 Net-_U1-Pad14_ Net-_U4-Pad2_ d_buffer
U5 Net-_U1-Pad11_ Net-_U10-Pad2_ d_buffer
U2 Net-_U1-Pad10_ Net-_U10-Pad4_ d_inverter
U10 Net-_U10-Pad1_ Net-_U10-Pad2_ unconnected-_U10-Pad3_ Net-_U10-Pad4_ Net-_U10-Pad5_ unconnected-_U10-Pad6_ d_dff
.end
