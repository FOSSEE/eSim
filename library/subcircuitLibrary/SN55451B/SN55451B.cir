.title KiCad schematic
D6 Net-_D6-Pad1_ Net-_D6-Pad2_ eSim_Diode
R6 /2Y Net-_Q10-Pad2_ 1k
Q10 Net-_D6-Pad2_ Net-_Q10-Pad2_ /2Y eSim_NPN
Q9 Net-_Q9-Pad1_ Net-_Q6-Pad1_ Net-_D6-Pad1_ eSim_NPN
R5 /VCC Net-_Q6-Pad1_ 1.6k
R8 Net-_Q9-Pad1_ /VCC 130
Q6 Net-_Q6-Pad1_ Net-_Q2-Pad1_ Net-_Q10-Pad2_ eSim_NPN
R10 /2Y Net-_D6-Pad2_ 500
Q12 Net-_Q12-Pad1_ Net-_D6-Pad2_ /2Y eSim_NPN
U1 /1A /1B /2A /2B /1Y Net-_Q12-Pad1_ /VCC /2Y PORT
R3 /VCC Net-_Q5-Pad1_ 1.6k
R1 Net-_Q1-Pad2_ /VCC 4k
Q1 Net-_Q1-Pad1_ Net-_Q1-Pad2_ /1A eSim_NPN
R9 /2Y Net-_D5-Pad2_ 500
Q11 /1Y Net-_D5-Pad2_ /2Y eSim_NPN
Q8 Net-_D5-Pad2_ Net-_Q5-Pad3_ /2Y eSim_NPN
R7 Net-_Q7-Pad1_ /VCC 130
Q7 Net-_Q7-Pad1_ Net-_Q5-Pad1_ Net-_D5-Pad1_ eSim_NPN
D5 Net-_D5-Pad1_ Net-_D5-Pad2_ eSim_Diode
D2 /2Y /2A eSim_Diode
D4 /2Y /2B eSim_Diode
Q4 Net-_Q2-Pad1_ Net-_Q2-Pad2_ /2B eSim_NPN
Q2 Net-_Q2-Pad1_ Net-_Q2-Pad2_ /2A eSim_NPN
R2 Net-_Q2-Pad2_ /VCC 4k
D3 /2Y /1B eSim_Diode
D1 /2Y /1A eSim_Diode
Q5 Net-_Q5-Pad1_ Net-_Q1-Pad1_ Net-_Q5-Pad3_ eSim_NPN
R4 /2Y Net-_Q5-Pad3_ 1k
Q3 Net-_Q1-Pad1_ Net-_Q1-Pad2_ /1B eSim_NPN
.end
