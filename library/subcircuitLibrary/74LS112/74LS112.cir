.title KiCad schematic
U1 Net-_U1-Pad1_ Net-_U1-Pad2_ Net-_U1-Pad3_ Net-_U1-Pad4_ Net-_U1-Pad5_ Net-_U1-Pad6_ Net-_U1-Pad7_ unconnected-_U1-Pad8_ Net-_U1-Pad9_ Net-_U1-Pad10_ Net-_U1-Pad11_ Net-_U1-Pad12_ Net-_U1-Pad13_ Net-_U1-Pad14_ Net-_U1-Pad15_ unconnected-_U1-Pad16_ PORT
X2 Net-_U1-Pad4_ Net-_U4-Pad2_ Net-_U1-Pad6_ Net-_U2-Pad2_ 3_and
U2 Net-_U2-Pad1_ Net-_U2-Pad2_ Net-_U1-Pad5_ d_nor
X1 Net-_U1-Pad4_ Net-_X1-Pad2_ unconnected-_X1-Pad3_ Net-_U2-Pad1_ 3_and
X5 Net-_U1-Pad5_ Net-_U3-Pad2_ Net-_U1-Pad15_ Net-_U5-Pad1_ 3_and
U5 Net-_U5-Pad1_ Net-_U5-Pad2_ Net-_U1-Pad6_ d_nor
X4 unconnected-_X4-Pad1_ Net-_X1-Pad2_ Net-_U1-Pad15_ Net-_U5-Pad2_ 3_and
X10 unconnected-_X10-Pad1_ Net-_X10-Pad2_ Net-_U1-Pad14_ Net-_U9-Pad2_ 3_and
X11 Net-_U1-Pad9_ Net-_U7-Pad2_ Net-_U1-Pad14_ Net-_U9-Pad1_ 3_and
X12 Net-_U1-Pad13_ Net-_U1-Pad11_ Net-_U1-Pad7_ Net-_U1-Pad14_ Net-_U8-Pad1_ 4_and
U8 Net-_U8-Pad1_ Net-_U8-Pad2_ d_inverter
U9 Net-_U9-Pad1_ Net-_U9-Pad2_ Net-_U1-Pad7_ d_nor
U3 Net-_U3-Pad1_ Net-_U3-Pad2_ d_inverter
X3 Net-_U1-Pad4_ Net-_U1-Pad5_ Net-_U1-Pad2_ Net-_U1-Pad1_ Net-_U3-Pad1_ 4_and
X6 Net-_U1-Pad1_ Net-_U1-Pad3_ Net-_U1-Pad6_ Net-_U1-Pad15_ Net-_U4-Pad1_ 4_and
U4 Net-_U4-Pad1_ Net-_U4-Pad2_ d_inverter
X9 Net-_U1-Pad10_ Net-_U1-Pad9_ Net-_U1-Pad12_ Net-_U1-Pad13_ Net-_U7-Pad1_ 4_and
U7 Net-_U7-Pad1_ Net-_U7-Pad2_ d_inverter
U6 Net-_U6-Pad1_ Net-_U6-Pad2_ Net-_U1-Pad9_ d_nor
X8 Net-_U1-Pad10_ Net-_U8-Pad2_ Net-_U1-Pad7_ Net-_U6-Pad2_ 3_and
X7 Net-_U1-Pad10_ Net-_X10-Pad2_ unconnected-_X7-Pad3_ Net-_U6-Pad1_ 3_and
.end
