.title KiCad schematic
U1 Net-_Q1-Pad1_ Net-_Q2-Pad3_ Net-_Q1-Pad3_ Net-_Q1-Pad2_ Net-_Q1-Pad1_ Net-_Q1-Pad1_ Net-_Q1-Pad1_ Net-_Q4-Pad2_ Net-_Q3-Pad2_ Net-_Q3-Pad3_ PORT
Q2 Net-_Q1-Pad1_ Net-_Q1-Pad3_ Net-_Q2-Pad3_ eSim_NPN
Q1 Net-_Q1-Pad1_ Net-_Q1-Pad2_ Net-_Q1-Pad3_ eSim_NPN
Q3 Net-_Q1-Pad1_ Net-_Q3-Pad2_ Net-_Q3-Pad3_ eSim_NPN
Q4 Net-_Q1-Pad1_ Net-_Q4-Pad2_ Net-_Q3-Pad2_ eSim_NPN
.end
