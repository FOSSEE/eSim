.title KiCad schematic
U2 B0 Net-_U2-Pad2_ adc_bridge_1
U3 A1 Net-_U3-Pad2_ adc_bridge_1
U4 B1 Net-_U4-Pad2_ adc_bridge_1
v6 B2 GND pulse
v5 A2 GND pulse
U5 A2 Net-_U5-Pad2_ adc_bridge_1
U6 B2 Net-_U6-Pad2_ adc_bridge_1
v8 B3 GND pulse
v7 A3 GND pulse
U8 B3 Net-_U8-Pad2_ adc_bridge_1
U7 A3 Net-_U7-Pad2_ adc_bridge_1
v1 A0 GND pulse
U1 A0 Net-_U1-Pad2_ adc_bridge_1
v2 B0 GND pulse
v4 B1 GND pulse
v3 A1 GND pulse
X1 Net-_U1-Pad2_ Net-_U2-Pad2_ Net-_U3-Pad2_ Net-_U4-Pad2_ Net-_U5-Pad2_ Net-_U6-Pad2_ Net-_U7-Pad2_ Net-_U8-Pad2_ Net-_U9-Pad1_ Net-_U11-Pad1_ Net-_U10-Pad1_ SN7485
U10 Net-_U10-Pad1_ AltB dac_bridge_1
U11 Net-_U11-Pad1_ AgtB dac_bridge_1
U9 Net-_U9-Pad1_ AeqB dac_bridge_1
.end
