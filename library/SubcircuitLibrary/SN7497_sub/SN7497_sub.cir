.title KiCad schematic
U1 Net-_U1-Pad1_ Net-_U1-Pad2_ Net-_U1-Pad3_ Net-_U1-Pad4_ Net-_U1-Pad5_ Net-_U1-Pad6_ Net-_U1-Pad7_ Net-_U1-Pad8_ PORT
U2 Net-_U11-Pad2_ Net-_U1-Pad1_ unconnected-_U2-Pad3_ unconnected-_U2-Pad4_ Net-_U11-Pad1_ unconnected-_U2-Pad6_ d_dff
U11 Net-_U11-Pad1_ Net-_U11-Pad2_ d_inverter
U14 Net-_U13-Pad1_ Net-_U1-Pad6_ Net-_U14-Pad3_ d_and
U18 Net-_U11-Pad1_ Net-_U1-Pad7_ Net-_U18-Pad3_ d_and
U20 Net-_U18-Pad3_ Net-_U14-Pad3_ Net-_U20-Pad3_ d_or
U13 Net-_U13-Pad1_ Net-_U13-Pad2_ d_inverter
U12 Net-_U12-Pad1_ Net-_U12-Pad2_ d_inverter
U4 Net-_U12-Pad2_ Net-_U13-Pad1_ unconnected-_U4-Pad3_ unconnected-_U4-Pad4_ Net-_U12-Pad1_ unconnected-_U4-Pad6_ d_dff
U10 Net-_U10-Pad1_ Net-_U10-Pad2_ d_inverter
U3 Net-_U13-Pad2_ Net-_U11-Pad1_ unconnected-_U3-Pad3_ unconnected-_U3-Pad4_ Net-_U13-Pad1_ unconnected-_U3-Pad6_ d_dff
U6 Net-_U6-Pad1_ Net-_U10-Pad1_ unconnected-_U6-Pad3_ unconnected-_U6-Pad4_ Net-_U17-Pad1_ unconnected-_U6-Pad6_ d_dff
U5 Net-_U10-Pad2_ Net-_U12-Pad1_ unconnected-_U5-Pad3_ unconnected-_U5-Pad4_ Net-_U10-Pad1_ unconnected-_U5-Pad6_ d_dff
U8 Net-_U17-Pad1_ Net-_U6-Pad1_ d_inverter
U9 Net-_U16-Pad1_ Net-_U7-Pad1_ d_inverter
U17 Net-_U17-Pad1_ Net-_U1-Pad3_ Net-_U17-Pad3_ d_and
U16 Net-_U16-Pad1_ Net-_U1-Pad2_ Net-_U16-Pad3_ d_and
U7 Net-_U7-Pad1_ Net-_U17-Pad1_ unconnected-_U7-Pad3_ unconnected-_U7-Pad4_ Net-_U16-Pad1_ unconnected-_U7-Pad6_ d_dff
U22 Net-_U17-Pad3_ Net-_U16-Pad3_ Net-_U22-Pad3_ d_or
U19 Net-_U10-Pad1_ Net-_U1-Pad4_ Net-_U19-Pad3_ d_and
U15 Net-_U12-Pad1_ Net-_U1-Pad5_ Net-_U15-Pad3_ d_and
U21 Net-_U15-Pad3_ Net-_U19-Pad3_ Net-_U21-Pad3_ d_or
U23 Net-_U20-Pad3_ Net-_U21-Pad3_ Net-_U23-Pad3_ d_or
U24 Net-_U23-Pad3_ Net-_U22-Pad3_ Net-_U1-Pad8_ d_or
.end
