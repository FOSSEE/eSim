* C:\FOSSEE\eSim\library\SubcircuitLibrary\TL317\TL317.cir

* EESchema Netlist Version 1.1 (Spice format) creation date: 05/11/26 15:31:52

* To exclude a component from the Spice Netlist add [Spice_Netlist_Enabled] user FIELD set to: N
* To reorder the component spice node sequence add [Spice_Node_Sequence] user FIELD and define sequence: 2,1,0

* Sheet Name: /
Q5  Net-_Q5-Pad1_ Net-_Q3-Pad2_ Net-_C1-Pad2_ eSim_NPN
Q2  Net-_Q10-Pad2_ Net-_Q10-Pad2_ Net-_Q2-Pad3_ eSim_PNP
Q3  Net-_Q10-Pad2_ Net-_Q3-Pad2_ Net-_Q3-Pad3_ eSim_NPN
Q4  Net-_Q3-Pad2_ Net-_Q10-Pad2_ Net-_Q4-Pad3_ eSim_PNP
R2  Net-_Q1-Pad3_ Net-_Q2-Pad3_ 310
R4  Net-_Q1-Pad3_ Net-_Q4-Pad3_ 310
Q1  Net-_D1-Pad2_ Net-_C1-Pad2_ Net-_Q1-Pad3_ eSim_PNP
Q7  Net-_Q6-Pad3_ Net-_Q10-Pad2_ Net-_Q7-Pad3_ eSim_PNP
R7  Net-_Q1-Pad3_ Net-_Q7-Pad3_ 190
R6  Net-_Q6-Pad3_ Net-_Q8-Pad1_ 11.5K
R3  Net-_Q3-Pad3_ Net-_C1-Pad2_ 195
Q9  Net-_Q11-Pad2_ Net-_Q8-Pad1_ Net-_Q6-Pad3_ eSim_PNP
Q6  Net-_C1-Pad2_ Net-_Q5-Pad1_ Net-_Q6-Pad3_ eSim_PNP
R8  Net-_Q8-Pad3_ Net-_C1-Pad2_ 5.3k
Q8  Net-_Q8-Pad1_ Net-_Q5-Pad1_ Net-_Q8-Pad3_ eSim_NPN
Q11  Net-_Q10-Pad1_ Net-_Q11-Pad2_ Net-_Q11-Pad3_ eSim_NPN
Q12  Net-_Q10-Pad1_ Net-_Q12-Pad2_ Net-_C1-Pad2_ eSim_NPN
R11  Net-_Q11-Pad3_ Net-_C1-Pad2_ 70
R9  Net-_Q11-Pad2_ Net-_C1-Pad2_ 5.7k
R12  Net-_Q12-Pad2_ Net-_C1-Pad2_ 5.1K
Q13  Net-_Q1-Pad3_ Net-_Q13-Pad2_ Net-_Q12-Pad2_ eSim_NPN
Q15  Net-_C1-Pad2_ Net-_C1-Pad1_ Net-_Q13-Pad2_ eSim_PNP
C1  Net-_C1-Pad1_ Net-_C1-Pad2_ 30pF
C2  Net-_C1-Pad1_ Net-_C2-Pad2_ 30pF
Q17  Net-_C1-Pad1_ Net-_C1-Pad2_ Net-_Q17-Pad3_ eSim_NPN
R14  Net-_Q17-Pad3_ Net-_C2-Pad2_ 10.8K
R15  Net-_Q19-Pad3_ Net-_Q17-Pad3_ 2.12K
Q19  Net-_Q16-Pad2_ Net-_C1-Pad2_ Net-_Q19-Pad3_ eSim_NPN
Q20  Net-_Q10-Pad1_ Net-_Q20-Pad2_ Net-_C1-Pad2_ eSim_NPN
Q16  Net-_C1-Pad1_ Net-_Q16-Pad2_ Net-_Q10-Pad1_ eSim_PNP
Q18  Net-_Q16-Pad2_ Net-_Q18-Pad2_ Net-_Q10-Pad1_ eSim_PNP
R16  Net-_Q18-Pad2_ Net-_Q16-Pad2_ 2.1K
R18  Net-_Q21-Pad1_ Net-_Q20-Pad2_ 360
Q21  Net-_Q21-Pad1_ Net-_Q10-Pad1_ Net-_Q1-Pad3_ eSim_PNP
Q22  Net-_Q1-Pad3_ Net-_Q21-Pad1_ Net-_Q22-Pad3_ eSim_NPN
R20  Net-_Q22-Pad3_ Net-_C1-Pad2_ 1.4
R19  Net-_Q20-Pad2_ Net-_C1-Pad2_ 670
R17  Net-_R17-Pad1_ Net-_C2-Pad2_ 40
R5  Net-_Q3-Pad2_ Net-_Q5-Pad1_ 124
R1  Net-_Q3-Pad2_ Net-_D1-Pad2_ 200K
D1  Net-_C1-Pad2_ Net-_D1-Pad2_ eSim_Diode
Q10  Net-_Q10-Pad1_ Net-_Q10-Pad2_ Net-_Q10-Pad3_ eSim_PNP
R10  Net-_Q1-Pad3_ Net-_Q10-Pad3_ 251
Q14  Net-_Q13-Pad2_ Net-_Q10-Pad2_ Net-_Q14-Pad3_ eSim_PNP
R13  Net-_Q1-Pad3_ Net-_Q14-Pad3_ 5.6K
U1  Net-_Q1-Pad3_ Net-_C1-Pad2_ Net-_C1-Pad2_ Net-_R17-Pad1_ ? Net-_C1-Pad2_ Net-_C1-Pad2_ ? PORT

.end
