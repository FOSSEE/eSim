.title KiCad schematic
Q38 Net-_Q38-Pad1_ Net-_Q34-Pad2_ Net-_Q34-Pad3_ eSim_PNP
Q39 Net-_J1-Pad2_ Net-_Q39-Pad2_ Net-_Q35-Pad2_ eSim_PNP
Q50 Net-_J1-Pad1_ Net-_C2-Pad1_ Net-_Q50-Pad3_ eSim_NPN
Q52 Net-_C2-Pad1_ Net-_Q50-Pad3_ Net-_Q51-Pad3_ eSim_NPN
Q47 Net-_C2-Pad1_ Net-_Q44-Pad3_ Net-_Q45-Pad1_ eSim_NPN
Q48 Net-_Q34-Pad2_ Net-_Q34-Pad2_ Net-_J1-Pad1_ eSim_PNP
R11 Net-_Q50-Pad3_ Net-_Q51-Pad3_ 20
Q51 Net-_J1-Pad2_ Net-_Q45-Pad1_ Net-_Q51-Pad3_ eSim_PNP
R9 Net-_Q45-Pad2_ Net-_Q41-Pad3_ 1k
Q45 Net-_Q45-Pad1_ Net-_Q45-Pad2_ Net-_J1-Pad2_ eSim_NPN
Q44 Net-_C2-Pad1_ Net-_C2-Pad1_ Net-_Q44-Pad3_ eSim_NPN
R10 Net-_Q44-Pad3_ Net-_Q45-Pad1_ 50k
R8 Net-_Q49-Pad2_ Net-_Q41-Pad3_ 1k
Q41 Net-_Q41-Pad1_ Net-_Q38-Pad1_ Net-_Q41-Pad3_ eSim_NPN
Q40 Net-_J1-Pad2_ Net-_C2-Pad2_ Net-_Q38-Pad1_ eSim_PNP
C2 Net-_C2-Pad1_ Net-_C2-Pad2_ 5p
U3 Net-_J1-Pad2_ Net-_Q41-Pad1_ zener
Q42 Net-_Q41-Pad1_ Net-_Q34-Pad2_ Net-_J1-Pad1_ eSim_PNP
Q43 Net-_C2-Pad1_ Net-_Q34-Pad2_ Net-_J1-Pad1_ eSim_PNP
Q46 Net-_C2-Pad1_ Net-_Q34-Pad2_ Net-_J1-Pad1_ eSim_PNP
Q49 Net-_C2-Pad1_ Net-_Q49-Pad2_ Net-_J1-Pad2_ eSim_NPN
R12 Net-_Q53-Pad3_ Net-_J1-Pad2_ 3k
J2 Net-_J1-Pad1_ Net-_J1-Pad2_ Net-_J2-Pad3_ jfet_n
Q53 Net-_Q34-Pad2_ Net-_J2-Pad3_ Net-_Q53-Pad3_ eSim_NPN
U1 Net-_Q24-Pad3_ Net-_Q2-Pad2_ Net-_Q12-Pad2_ Net-_J1-Pad2_ Net-_Q39-Pad2_ Net-_Q29-Pad2_ Net-_Q51-Pad3_ Net-_J1-Pad1_ PORT
Q54 Net-_J2-Pad3_ Net-_Q53-Pad3_ Net-_J1-Pad2_ eSim_NPN
Q7 Net-_Q1-Pad3_ Net-_Q10-Pad2_ Net-_Q10-Pad3_ eSim_PNP
R1 Net-_Q10-Pad3_ Net-_J1-Pad1_ 1k
Q4 Net-_Q1-Pad2_ Net-_Q2-Pad3_ Net-_Q10-Pad1_ eSim_PNP
Q3 Net-_Q2-Pad3_ Net-_Q2-Pad3_ Net-_Q10-Pad1_ eSim_PNP
Q8 Net-_C1-Pad2_ Net-_Q12-Pad3_ Net-_Q10-Pad1_ eSim_PNP
Q9 Net-_Q12-Pad3_ Net-_Q12-Pad3_ Net-_Q10-Pad1_ eSim_PNP
Q13 Net-_J1-Pad2_ Net-_C1-Pad2_ Net-_Q11-Pad1_ eSim_PNP
Q6 Net-_C1-Pad2_ Net-_Q1-Pad2_ Net-_J1-Pad2_ eSim_NPN
Q12 Net-_J1-Pad2_ Net-_Q12-Pad2_ Net-_Q12-Pad3_ eSim_PNP
C1 Net-_C1-Pad1_ Net-_C1-Pad2_ 5p
Q16 Net-_C1-Pad1_ Net-_Q10-Pad2_ Net-_J1-Pad1_ eSim_PNP
Q19 Net-_C1-Pad1_ Net-_Q10-Pad2_ Net-_J1-Pad1_ eSim_PNP
Q21 Net-_Q10-Pad2_ Net-_Q10-Pad2_ Net-_J1-Pad1_ eSim_PNP
Q17 Net-_C1-Pad1_ Net-_C1-Pad1_ Net-_Q17-Pad3_ eSim_NPN
Q20 Net-_C1-Pad1_ Net-_Q17-Pad3_ Net-_Q18-Pad1_ eSim_NPN
Q5 Net-_Q1-Pad2_ Net-_Q1-Pad2_ Net-_J1-Pad2_ eSim_NPN
Q1 Net-_J1-Pad2_ Net-_Q1-Pad2_ Net-_Q1-Pad3_ eSim_PNP
Q2 Net-_J1-Pad2_ Net-_Q2-Pad2_ Net-_Q2-Pad3_ eSim_PNP
Q15 Net-_Q14-Pad1_ Net-_Q10-Pad2_ Net-_J1-Pad1_ eSim_PNP
Q10 Net-_Q10-Pad1_ Net-_Q10-Pad2_ Net-_Q10-Pad3_ eSim_PNP
Q11 Net-_Q11-Pad1_ Net-_Q10-Pad2_ Net-_Q10-Pad3_ eSim_PNP
U2 Net-_J1-Pad2_ Net-_Q14-Pad1_ zener
Q14 Net-_Q14-Pad1_ Net-_Q11-Pad1_ Net-_Q14-Pad3_ eSim_NPN
R3 Net-_Q18-Pad2_ Net-_Q14-Pad3_ 1k
R2 Net-_Q22-Pad2_ Net-_Q14-Pad3_ 1k
Q18 Net-_Q18-Pad1_ Net-_Q18-Pad2_ Net-_J1-Pad2_ eSim_NPN
R4 Net-_Q17-Pad3_ Net-_Q18-Pad1_ 50k
Q22 Net-_C1-Pad1_ Net-_Q22-Pad2_ Net-_J1-Pad2_ eSim_NPN
R5 Net-_Q23-Pad3_ Net-_Q24-Pad3_ 20
Q23 Net-_J1-Pad1_ Net-_C1-Pad1_ Net-_Q23-Pad3_ eSim_NPN
Q29 Net-_J1-Pad2_ Net-_Q29-Pad2_ Net-_Q29-Pad3_ eSim_PNP
Q25 Net-_C1-Pad1_ Net-_Q23-Pad3_ Net-_Q24-Pad3_ eSim_NPN
Q24 Net-_J1-Pad2_ Net-_Q18-Pad1_ Net-_Q24-Pad3_ eSim_PNP
J1 Net-_J1-Pad1_ Net-_J1-Pad2_ Net-_J1-Pad3_ jfet_n
Q26 Net-_Q10-Pad2_ Net-_J1-Pad3_ Net-_Q26-Pad3_ eSim_NPN
R6 Net-_Q26-Pad3_ Net-_J1-Pad2_ 3k
Q28 Net-_J1-Pad2_ Net-_Q28-Pad2_ Net-_Q28-Pad3_ eSim_PNP
Q27 Net-_J1-Pad3_ Net-_Q26-Pad3_ Net-_J1-Pad2_ eSim_NPN
Q37 Net-_Q30-Pad3_ Net-_Q34-Pad2_ Net-_Q34-Pad3_ eSim_PNP
R7 Net-_Q34-Pad3_ Net-_J1-Pad1_ 1k
Q34 Net-_Q28-Pad3_ Net-_Q34-Pad2_ Net-_Q34-Pad3_ eSim_PNP
Q32 Net-_Q28-Pad2_ Net-_Q28-Pad2_ Net-_J1-Pad2_ eSim_NPN
Q36 Net-_Q35-Pad2_ Net-_Q35-Pad2_ Net-_Q30-Pad3_ eSim_PNP
Q30 Net-_Q29-Pad3_ Net-_Q29-Pad3_ Net-_Q30-Pad3_ eSim_PNP
Q31 Net-_Q28-Pad2_ Net-_Q29-Pad3_ Net-_Q30-Pad3_ eSim_PNP
Q35 Net-_C2-Pad2_ Net-_Q35-Pad2_ Net-_Q30-Pad3_ eSim_PNP
Q33 Net-_C2-Pad2_ Net-_Q28-Pad2_ Net-_J1-Pad2_ eSim_NPN
.end
