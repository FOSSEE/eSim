.title KiCad schematic
U9 Net-_U13-Pad1_ Net-_U17-Pad1_ d_inverter
U14 Net-_U10-Pad1_ Net-_U13-Pad2_ Net-_U14-Pad3_ d_or
U22 Net-_U14-Pad3_ Net-_U22-Pad2_ d_inverter
U24 Net-_U17-Pad3_ Net-_U24-Pad2_ d_inverter
U17 Net-_U17-Pad1_ Net-_U13-Pad2_ Net-_U17-Pad3_ d_or
U21 Net-_U13-Pad3_ Net-_U21-Pad2_ d_inverter
U29 Net-_U21-Pad2_ Net-_U24-Pad2_ Net-_U1-Pad2_ Net-_U2-Pad2_ Net-_U2-Pad2_ Net-_U29-Pad6_ Net-_U29-Pad7_ d_srlatch
U30 Net-_U22-Pad2_ Net-_U25-Pad2_ Net-_U1-Pad2_ Net-_U2-Pad2_ Net-_U2-Pad2_ Net-_U30-Pad6_ Net-_U30-Pad7_ d_srlatch
U13 Net-_U13-Pad1_ Net-_U13-Pad2_ Net-_U13-Pad3_ d_or
U39 Net-_U31-Pad6_ Net-_U31-Pad6_ Net-_U39-Pad3_ d_nor
U37 Net-_U31-Pad7_ Net-_U32-Pad6_ Net-_U37-Pad3_ d_nor
U40 Net-_U32-Pad6_ Net-_U31-Pad6_ Net-_U40-Pad3_ d_nor
U3 Net-_U3-Pad1_ Net-_U3-Pad2_ Net-_U3-Pad3_ Net-_U3-Pad4_ Net-_U3-Pad5_ Net-_U3-Pad6_ Net-_U3-Pad7_ Net-_U3-Pad8_ Net-_U3-Pad9_ Net-_U3-Pad10_ Net-_U3-Pad11_ unconnected-_U3-Pad12_ Net-_U3-Pad13_ Net-_U3-Pad14_ Net-_U3-Pad15_ Net-_U3-Pad16_ Net-_U3-Pad17_ Net-_U3-Pad18_ Net-_U3-Pad19_ Net-_U3-Pad20_ Net-_U3-Pad21_ Net-_U3-Pad22_ Net-_U3-Pad23_ unconnected-_U3-Pad24_ PORT
U32 Net-_U27-Pad2_ Net-_U28-Pad2_ Net-_U1-Pad2_ Net-_U2-Pad2_ Net-_U2-Pad2_ Net-_U32-Pad6_ Net-_U32-Pad7_ d_srlatch
U31 Net-_U23-Pad2_ Net-_U26-Pad2_ Net-_U1-Pad2_ Net-_U2-Pad2_ Net-_U2-Pad2_ Net-_U31-Pad6_ Net-_U31-Pad7_ d_srlatch
U41 Net-_U3-Pad23_ Net-_U41-Pad2_ d_inverter
U36 Net-_U30-Pad6_ Net-_U29-Pad6_ Net-_U36-Pad3_ d_nor
U33 Net-_U29-Pad7_ Net-_U30-Pad6_ Net-_U33-Pad3_ d_nor
U38 Net-_U31-Pad7_ Net-_U32-Pad7_ Net-_U38-Pad3_ d_nor
U35 Net-_U29-Pad6_ Net-_U29-Pad6_ Net-_U35-Pad3_ d_nor
U34 Net-_U29-Pad7_ Net-_U30-Pad7_ Net-_U34-Pad3_ d_nor
U12 Net-_U12-Pad1_ Net-_U12-Pad2_ d_inverter
U10 Net-_U10-Pad1_ Net-_U10-Pad2_ d_inverter
U18 Net-_U10-Pad2_ Net-_U13-Pad2_ Net-_U18-Pad3_ d_or
U25 Net-_U18-Pad3_ Net-_U25-Pad2_ d_inverter
U11 Net-_U11-Pad1_ Net-_U11-Pad2_ d_inverter
U23 Net-_U15-Pad3_ Net-_U23-Pad2_ d_inverter
U26 Net-_U19-Pad3_ Net-_U26-Pad2_ d_inverter
U19 Net-_U11-Pad2_ Net-_U13-Pad2_ Net-_U19-Pad3_ d_or
U15 Net-_U11-Pad1_ Net-_U13-Pad2_ Net-_U15-Pad3_ d_or
U16 Net-_U12-Pad1_ Net-_U13-Pad2_ Net-_U16-Pad3_ d_or
U28 Net-_U20-Pad3_ Net-_U28-Pad2_ d_inverter
U27 Net-_U16-Pad3_ Net-_U27-Pad2_ d_inverter
U20 Net-_U12-Pad2_ Net-_U13-Pad2_ Net-_U20-Pad3_ d_or
v2 Net-_U2-Pad1_ GND 0
U2 Net-_U2-Pad1_ Net-_U2-Pad2_ adc_bridge_1
U1 Net-_U1-Pad1_ Net-_U1-Pad2_ adc_bridge_1
v1 Net-_U1-Pad1_ GND 5
U6 Net-_U3-Pad21_ Net-_U11-Pad1_ d_inverter
U4 Net-_U3-Pad2_ Net-_U13-Pad1_ d_inverter
U5 Net-_U3-Pad3_ Net-_U10-Pad1_ d_inverter
U7 Net-_U3-Pad1_ Net-_U13-Pad2_ d_inverter
U8 Net-_U3-Pad22_ Net-_U12-Pad1_ d_inverter
X9 Net-_U37-Pad3_ Net-_U34-Pad3_ Net-_U41-Pad2_ Net-_U50-Pad1_ 3_and
X10 Net-_U37-Pad3_ Net-_U35-Pad3_ Net-_U41-Pad2_ Net-_U51-Pad1_ 3_and
U51 Net-_U51-Pad1_ Net-_U51-Pad2_ d_inverter
U50 Net-_U50-Pad1_ Net-_U50-Pad2_ d_inverter
U71 Net-_U55-Pad2_ Net-_U3-Pad13_ d_buffer
U73 Net-_U57-Pad2_ Net-_U3-Pad15_ d_buffer
U72 Net-_U56-Pad2_ Net-_U3-Pad16_ d_buffer
U67 Net-_U51-Pad2_ Net-_U3-Pad17_ d_buffer
U68 Net-_U52-Pad2_ Net-_U3-Pad20_ d_buffer
U69 Net-_U53-Pad2_ Net-_U3-Pad19_ d_buffer
U70 Net-_U54-Pad2_ Net-_U3-Pad14_ d_buffer
X13 Net-_U40-Pad3_ Net-_U34-Pad3_ Net-_U41-Pad2_ Net-_U54-Pad1_ 3_and
X14 Net-_U40-Pad3_ Net-_U35-Pad3_ Net-_U41-Pad2_ Net-_U55-Pad1_ 3_and
X16 Net-_U40-Pad3_ Net-_U36-Pad3_ Net-_U41-Pad2_ Net-_U57-Pad1_ 3_and
X15 Net-_U40-Pad3_ Net-_U33-Pad3_ Net-_U41-Pad2_ Net-_U56-Pad1_ 3_and
U57 Net-_U57-Pad1_ Net-_U57-Pad2_ d_inverter
U56 Net-_U56-Pad1_ Net-_U56-Pad2_ d_inverter
U55 Net-_U55-Pad1_ Net-_U55-Pad2_ d_inverter
U54 Net-_U54-Pad1_ Net-_U54-Pad2_ d_inverter
U52 Net-_U52-Pad1_ Net-_U52-Pad2_ d_inverter
U53 Net-_U53-Pad1_ Net-_U53-Pad2_ d_inverter
X12 Net-_U37-Pad3_ Net-_U36-Pad3_ Net-_U41-Pad2_ Net-_U53-Pad1_ 3_and
X11 Net-_U37-Pad3_ Net-_U33-Pad3_ Net-_U41-Pad2_ Net-_U52-Pad1_ 3_and
U65 Net-_U49-Pad2_ Net-_U3-Pad4_ d_buffer
U64 Net-_U48-Pad2_ Net-_U3-Pad5_ d_buffer
U66 Net-_U50-Pad2_ Net-_U3-Pad18_ d_buffer
U46 Net-_U46-Pad1_ Net-_U46-Pad2_ d_inverter
U48 Net-_U48-Pad1_ Net-_U48-Pad2_ d_inverter
U47 Net-_U47-Pad1_ Net-_U47-Pad2_ d_inverter
U49 Net-_U49-Pad1_ Net-_U49-Pad2_ d_inverter
U62 Net-_U46-Pad2_ Net-_U3-Pad7_ d_buffer
U63 Net-_U47-Pad2_ Net-_U3-Pad6_ d_buffer
U61 Net-_U45-Pad2_ Net-_U3-Pad8_ d_buffer
U59 Net-_U43-Pad2_ Net-_U3-Pad9_ d_buffer
U58 Net-_U42-Pad2_ Net-_U3-Pad11_ d_buffer
U60 Net-_U44-Pad2_ Net-_U3-Pad10_ d_buffer
X4 Net-_U38-Pad3_ Net-_U36-Pad3_ Net-_U41-Pad2_ Net-_U45-Pad1_ 3_and
X5 Net-_U39-Pad3_ Net-_U34-Pad3_ Net-_U41-Pad2_ Net-_U46-Pad1_ 3_and
X6 Net-_U39-Pad3_ Net-_U33-Pad3_ Net-_U41-Pad2_ Net-_U47-Pad1_ 3_and
X2 Net-_U38-Pad3_ Net-_U35-Pad3_ Net-_U41-Pad2_ Net-_U43-Pad1_ 3_and
X3 Net-_U38-Pad3_ Net-_U33-Pad3_ Net-_U41-Pad2_ Net-_U44-Pad1_ 3_and
X7 Net-_U39-Pad3_ Net-_U33-Pad3_ Net-_U41-Pad2_ Net-_U48-Pad1_ 3_and
X8 Net-_U39-Pad3_ Net-_U36-Pad3_ Net-_U41-Pad2_ Net-_U49-Pad1_ 3_and
U45 Net-_U45-Pad1_ Net-_U45-Pad2_ d_inverter
U43 Net-_U43-Pad1_ Net-_U43-Pad2_ d_inverter
U44 Net-_U44-Pad1_ Net-_U44-Pad2_ d_inverter
X1 Net-_U38-Pad3_ Net-_U34-Pad3_ Net-_U41-Pad2_ Net-_U42-Pad1_ 3_and
U42 Net-_U42-Pad1_ Net-_U42-Pad2_ d_inverter
.end
