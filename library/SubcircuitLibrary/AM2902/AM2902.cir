.title KiCad schematic
U12 /G2 Net-_U12-Pad2_ Net-_U12-Pad3_ d_or
U10 Net-_U10-Pad1_ /P0 Net-_U10-Pad3_ d_and
U24 /G0 Net-_U19-Pad3_ Net-_U24-Pad3_ d_or
U25 Net-_U23-Pad3_ Net-_U20-Pad3_ Net-_U25-Pad3_ d_or
U23 Net-_U12-Pad3_ Net-_U23-Pad2_ Net-_U23-Pad3_ d_or
U19 /P0 /CN Net-_U19-Pad3_ d_and
U20 Net-_U10-Pad3_ /CN Net-_U20-Pad3_ d_and
U21 /G1 Net-_U11-Pad3_ Net-_U21-Pad3_ d_or
U26 Net-_U21-Pad3_ Net-_U17-Pad3_ Net-_U26-Pad3_ d_or
U3 /CN /G0 /G1 /G2 /G3 /P0 /P1 /P2 /P3 Net-_U24-Pad3_ Net-_U26-Pad3_ Net-_U25-Pad3_ Net-_U28-Pad3_ Net-_U22-Pad3_ Net-_U27-Pad3_ PORT
U17 Net-_U13-Pad3_ /CN Net-_U17-Pad3_ d_and
U18 Net-_U14-Pad3_ /CN Net-_U18-Pad3_ d_and
U27 Net-_U2-Pad3_ Net-_U13-Pad3_ Net-_U27-Pad3_ d_and
U28 Net-_U22-Pad3_ Net-_U18-Pad3_ Net-_U28-Pad3_ d_or
U9 Net-_U10-Pad1_ /G0 Net-_U23-Pad2_ d_and
U1 /P3 /G2 Net-_U1-Pad3_ d_and
U2 /P3 /P2 Net-_U2-Pad3_ d_and
U4 /P2 /G1 Net-_U12-Pad2_ d_and
U7 /G3 Net-_U1-Pad3_ Net-_U16-Pad1_ d_or
U5 /P2 /P1 Net-_U10-Pad1_ d_and
U11 /P1 /G0 Net-_U11-Pad3_ d_and
U13 /P1 /P0 Net-_U13-Pad3_ d_and
U14 Net-_U14-Pad1_ /P0 Net-_U14-Pad3_ d_and
U16 Net-_U16-Pad1_ Net-_U16-Pad2_ Net-_U16-Pad3_ d_or
U15 Net-_U14-Pad1_ /G0 Net-_U15-Pad3_ d_and
U8 Net-_U2-Pad3_ /P1 Net-_U14-Pad1_ d_and
U6 Net-_U2-Pad3_ /G1 Net-_U16-Pad2_ d_and
U22 Net-_U16-Pad3_ Net-_U15-Pad3_ Net-_U22-Pad3_ d_or
.end
