.title KiCad schematic
U18 Net-_U15-Pad2_ Net-_U18-Pad2_ d_buffer
U24 Net-_U13-Pad1_ Net-_U14-Pad1_ Net-_U15-Pad1_ Net-_U22-Pad2_ Net-_U23-Pad2_ Net-_U1-Pad1_ Net-_U2-Pad1_ Net-_U24-Pad8_ Net-_U24-Pad9_ Net-_U24-Pad10_ Net-_U24-Pad11_ PORT
U13 Net-_U13-Pad1_ Net-_U13-Pad2_ d_inverter
U17 Net-_U14-Pad2_ Net-_U17-Pad2_ d_buffer
U16 Net-_U13-Pad2_ Net-_U16-Pad2_ d_buffer
X11 Net-_U14-Pad2_ Net-_U13-Pad2_ Net-_U18-Pad2_ Net-_SC3-Pad3_ 3_and
X12 Net-_U18-Pad2_ Net-_U17-Pad2_ Net-_U16-Pad2_ Net-_SC3-Pad4_ 3_and
X10 Net-_U13-Pad2_ Net-_U15-Pad2_ Net-_U17-Pad2_ Net-_SC3-Pad2_ 3_and
X9 Net-_U14-Pad2_ Net-_U15-Pad2_ Net-_U16-Pad2_ Net-_SC3-Pad1_ 3_and
U15 Net-_U15-Pad1_ Net-_U15-Pad2_ d_inverter
U14 Net-_U14-Pad1_ Net-_U14-Pad2_ d_inverter
U5 Net-_U2-Pad2_ Net-_U5-Pad2_ d_buffer
U1 Net-_U1-Pad1_ Net-_U1-Pad2_ d_inverter
U4 Net-_U1-Pad2_ Net-_U4-Pad2_ d_buffer
U3 Net-_U24-Pad8_ Net-_U3-Pad2_ d_inverter
U2 Net-_U2-Pad1_ Net-_U2-Pad2_ d_inverter
U6 Net-_U3-Pad2_ Net-_U6-Pad2_ d_buffer
X1 Net-_U2-Pad2_ Net-_U3-Pad2_ Net-_U4-Pad2_ Net-_SC1-Pad1_ 3_and
X2 Net-_U1-Pad2_ Net-_U3-Pad2_ Net-_U5-Pad2_ Net-_SC1-Pad2_ 3_and
X3 Net-_U2-Pad2_ Net-_U1-Pad2_ Net-_U6-Pad2_ Net-_SC1-Pad3_ 3_and
X4 Net-_U6-Pad2_ Net-_U5-Pad2_ Net-_U4-Pad2_ Net-_SC1-Pad4_ 3_and
X5 Net-_U11-Pad1_ Net-_U12-Pad1_ Net-_U10-Pad2_ Net-_SC2-Pad1_ 3_and
U11 Net-_U11-Pad1_ Net-_U11-Pad2_ d_buffer
U10 Net-_U10-Pad1_ Net-_U10-Pad2_ d_buffer
X6 Net-_U10-Pad1_ Net-_U12-Pad1_ Net-_U11-Pad2_ Net-_SC2-Pad2_ 3_and
X7 Net-_U11-Pad1_ Net-_U10-Pad1_ Net-_U12-Pad2_ Net-_SC2-Pad3_ 3_and
X8 Net-_U12-Pad2_ Net-_U11-Pad2_ Net-_U10-Pad2_ Net-_SC2-Pad4_ 3_and
U8 Net-_U24-Pad10_ Net-_U11-Pad1_ d_inverter
U9 Net-_U24-Pad11_ Net-_U12-Pad1_ d_inverter
U7 Net-_U24-Pad9_ Net-_U10-Pad1_ d_inverter
U12 Net-_U12-Pad1_ Net-_U12-Pad2_ d_buffer
SC1 Net-_SC1-Pad1_ Net-_SC1-Pad2_ Net-_SC1-Pad3_ Net-_SC1-Pad4_ Net-_SC1-Pad5_ sky130_stdcells__nor4_1
SC2 Net-_SC2-Pad1_ Net-_SC2-Pad2_ Net-_SC2-Pad3_ Net-_SC2-Pad4_ Net-_SC2-Pad5_ sky130_stdcells__nor4_1
U20 Net-_SC2-Pad5_ Net-_U20-Pad2_ d_inverter
U21 Net-_SC3-Pad5_ Net-_U21-Pad2_ d_inverter
U22 Net-_SC4-Pad5_ Net-_U22-Pad2_ d_inverter
SC4 Net-_SC4-Pad1_ Net-_SC4-Pad2_ Net-_SC4-Pad3_ Net-_SC4-Pad4_ Net-_SC4-Pad5_ sky130_stdcells__nor4_1
X13 Net-_SC2-Pad5_ Net-_SC3-Pad5_ Net-_U19-Pad2_ Net-_SC4-Pad1_ 3_and
X14 Net-_SC1-Pad5_ Net-_SC3-Pad5_ Net-_U20-Pad2_ Net-_SC4-Pad2_ 3_and
U19 Net-_SC1-Pad5_ Net-_U19-Pad2_ d_inverter
X16 Net-_U19-Pad2_ Net-_U20-Pad2_ Net-_U21-Pad2_ Net-_SC4-Pad4_ 3_and
X15 Net-_SC1-Pad5_ Net-_SC2-Pad5_ Net-_U21-Pad2_ Net-_SC4-Pad3_ 3_and
SC3 Net-_SC3-Pad1_ Net-_SC3-Pad2_ Net-_SC3-Pad3_ Net-_SC3-Pad4_ Net-_SC3-Pad5_ sky130_stdcells__nor4_1
X20 Net-_SC2-Pad5_ Net-_SC1-Pad5_ Net-_SC3-Pad5_ Net-_SC5-Pad4_ 3_and
X19 Net-_U20-Pad2_ Net-_U19-Pad2_ Net-_SC3-Pad5_ Net-_SC5-Pad3_ 3_and
U23 Net-_SC5-Pad5_ Net-_U23-Pad2_ d_inverter
SC5 Net-_SC5-Pad1_ Net-_SC5-Pad2_ Net-_SC5-Pad3_ Net-_SC5-Pad4_ Net-_SC5-Pad5_ sky130_stdcells__nor4_1
X18 Net-_SC2-Pad5_ Net-_U19-Pad2_ Net-_U21-Pad2_ Net-_SC5-Pad2_ 3_and
X17 Net-_U20-Pad2_ Net-_U21-Pad2_ Net-_SC1-Pad5_ Net-_SC5-Pad1_ 3_and
.end
