.title KiCad schematic
U1 Net-_U1-Pad1_ Net-_U1-Pad2_ Net-_U1-Pad3_ Net-_U1-Pad4_ Net-_U1-Pad5_ Net-_U1-Pad6_ Net-_U1-Pad7_ Net-_U1-Pad9_ Net-_U1-Pad10_ Net-_U1-Pad11_ Net-_U1-Pad12_ Net-_U1-Pad13_ Net-_U1-Pad14_ Net-_U1-Pad15_ PORT
U25 Net-_U17-Pad2_ Net-_U25-Pad2_ Net-_U1-Pad7_ d_nand
U28 Net-_U20-Pad2_ Net-_U25-Pad2_ Net-_U1-Pad4_ d_nand
U26 Net-_U18-Pad2_ Net-_U25-Pad2_ Net-_U1-Pad6_ d_nand
U29 Net-_U21-Pad2_ Net-_U29-Pad2_ Net-_U1-Pad9_ d_nand
U27 Net-_U19-Pad2_ Net-_U25-Pad2_ Net-_U1-Pad5_ d_nand
U9 Net-_U10-Pad1_ Net-_U11-Pad2_ Net-_U17-Pad1_ d_nand
U17 Net-_U17-Pad1_ Net-_U17-Pad2_ d_inverter
U30 Net-_U22-Pad2_ Net-_U29-Pad2_ Net-_U1-Pad10_ d_nand
U31 Net-_U23-Pad2_ Net-_U29-Pad2_ Net-_U1-Pad11_ d_nand
U32 Net-_U24-Pad2_ Net-_U29-Pad2_ Net-_U1-Pad12_ d_nand
U16 Net-_U1-Pad3_ Net-_U1-Pad13_ Net-_U16-Pad3_ d_nand
U23 Net-_U15-Pad3_ Net-_U23-Pad2_ d_inverter
U24 Net-_U16-Pad3_ Net-_U24-Pad2_ d_inverter
U7 Net-_U5-Pad2_ Net-_U1-Pad1_ Net-_U25-Pad2_ d_and
U8 Net-_U6-Pad2_ Net-_U4-Pad2_ Net-_U29-Pad2_ d_and
U5 Net-_U1-Pad2_ Net-_U5-Pad2_ d_inverter
U4 Net-_U1-Pad14_ Net-_U4-Pad2_ d_inverter
U6 Net-_U1-Pad15_ Net-_U6-Pad2_ d_inverter
U3 Net-_U1-Pad13_ Net-_U11-Pad2_ d_inverter
U2 Net-_U1-Pad3_ Net-_U10-Pad1_ d_inverter
U10 Net-_U10-Pad1_ Net-_U1-Pad13_ Net-_U10-Pad3_ d_nand
U18 Net-_U10-Pad3_ Net-_U18-Pad2_ d_inverter
U11 Net-_U1-Pad3_ Net-_U11-Pad2_ Net-_U11-Pad3_ d_nand
U21 Net-_U13-Pad3_ Net-_U21-Pad2_ d_inverter
U14 Net-_U10-Pad1_ Net-_U1-Pad13_ Net-_U14-Pad3_ d_nand
U12 Net-_U1-Pad3_ Net-_U1-Pad13_ Net-_U12-Pad3_ d_nand
U13 Net-_U10-Pad1_ Net-_U11-Pad2_ Net-_U13-Pad3_ d_nand
U19 Net-_U11-Pad3_ Net-_U19-Pad2_ d_inverter
U20 Net-_U12-Pad3_ Net-_U20-Pad2_ d_inverter
U15 Net-_U1-Pad3_ Net-_U11-Pad2_ Net-_U15-Pad3_ d_nand
U22 Net-_U14-Pad3_ Net-_U22-Pad2_ d_inverter
.end
