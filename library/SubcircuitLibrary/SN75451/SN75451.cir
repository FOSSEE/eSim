* C:\FOSSEE\eSim\library\SubcircuitLibrary\SN75451\SN75451.cir

* EESchema Netlist Version 1.1 (Spice format) creation date: 05/09/26 19:08:15

* To exclude a component from the Spice Netlist add [Spice_Netlist_Enabled] user FIELD set to: N
* To reorder the component spice node sequence add [Spice_Node_Sequence] user FIELD and define sequence: 2,1,0

* Sheet Name: /
Q3  Net-_Q3-Pad1_ Net-_Q1-Pad1_ Net-_Q3-Pad3_ eSim_NPN
Q4  Net-_Q4-Pad1_ Net-_Q3-Pad1_ Net-_D3-Pad1_ eSim_NPN
D3  Net-_D3-Pad1_ Net-_D3-Pad2_ eSim_Diode
Q5  Net-_D3-Pad2_ Net-_Q3-Pad3_ Net-_D1-Pad1_ eSim_NPN
R3  Net-_Q3-Pad3_ Net-_D1-Pad1_ 1K
R5  Net-_D3-Pad2_ Net-_D1-Pad1_ 500
Q6  Net-_Q6-Pad1_ Net-_D3-Pad2_ Net-_D1-Pad1_ eSim_NPN
Q2  Net-_Q1-Pad1_ Net-_Q1-Pad2_ Net-_D2-Pad2_ eSim_NPN
Q1  Net-_Q1-Pad1_ Net-_Q1-Pad2_ Net-_D1-Pad2_ eSim_NPN
D1  Net-_D1-Pad1_ Net-_D1-Pad2_ eSim_Diode
D2  Net-_D1-Pad1_ Net-_D2-Pad2_ eSim_Diode
R1  Net-_R1-Pad1_ Net-_Q1-Pad2_ 4K
R2  Net-_R1-Pad1_ Net-_Q3-Pad1_ 1.6K
R4  Net-_R1-Pad1_ Net-_Q4-Pad1_ 130
Q9  Net-_Q10-Pad2_ Net-_Q7-Pad1_ Net-_Q11-Pad2_ eSim_NPN
Q10  Net-_Q10-Pad1_ Net-_Q10-Pad2_ Net-_D6-Pad1_ eSim_NPN
D6  Net-_D6-Pad1_ Net-_D6-Pad2_ eSim_Diode
Q11  Net-_D6-Pad2_ Net-_Q11-Pad2_ Net-_D1-Pad1_ eSim_NPN
R8  Net-_Q11-Pad2_ Net-_D1-Pad1_ 1K
R10  Net-_D6-Pad2_ Net-_D1-Pad1_ 500
Q12  Net-_Q12-Pad1_ Net-_D6-Pad2_ Net-_D1-Pad1_ eSim_NPN
Q8  Net-_Q7-Pad1_ Net-_Q7-Pad2_ Net-_D5-Pad2_ eSim_NPN
Q7  Net-_Q7-Pad1_ Net-_Q7-Pad2_ Net-_D4-Pad2_ eSim_NPN
D4  Net-_D1-Pad1_ Net-_D4-Pad2_ eSim_Diode
D5  Net-_D1-Pad1_ Net-_D5-Pad2_ eSim_Diode
R6  Net-_R1-Pad1_ Net-_Q7-Pad2_ 4K
R7  Net-_R1-Pad1_ Net-_Q10-Pad2_ 1.6K
R9  Net-_R1-Pad1_ Net-_Q10-Pad1_ 130
U1  Net-_D1-Pad2_ Net-_D2-Pad2_ Net-_Q6-Pad1_ Net-_D1-Pad1_ Net-_Q12-Pad1_ Net-_D4-Pad2_ Net-_D5-Pad2_ Net-_R1-Pad1_ PORT

.end
