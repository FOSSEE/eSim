.title KiCad schematic
U1 Net-_U1-Pad1_ Net-_U1-Pad2_ Net-_U1-Pad3_ Net-_U1-Pad4_ Net-_U1-Pad5_ Net-_U1-Pad6_ Net-_U1-Pad7_ unconnected-_U1-Pad8_ Net-_U1-Pad9_ Net-_U1-Pad10_ Net-_U1-Pad11_ Net-_U1-Pad12_ Net-_U1-Pad13_ Net-_U1-Pad14_ Net-_U1-Pad15_ unconnected-_U1-Pad16_ PORT
U32 Net-_U24-Pad6_ Net-_U32-Pad2_ d_inverter
U36 Net-_U32-Pad2_ Net-_U33-Pad2_ Net-_U1-Pad6_ d_tristate
U31 Net-_U23-Pad6_ Net-_U31-Pad2_ d_inverter
U35 Net-_U31-Pad2_ Net-_U33-Pad2_ Net-_U1-Pad5_ d_tristate
U24 Net-_U20-Pad3_ Net-_U1-Pad7_ Net-_U24-Pad3_ Net-_U1-Pad15_ Net-_U15-Pad1_ Net-_U24-Pad6_ d_dff
U23 Net-_U19-Pad3_ Net-_U1-Pad7_ Net-_U23-Pad3_ Net-_U1-Pad15_ Net-_U13-Pad1_ Net-_U23-Pad6_ d_dff
U28 Net-_U24-Pad3_ d_pulldown
U4 Net-_U1-Pad9_ Net-_U4-Pad2_ d_inverter
U5 Net-_U1-Pad10_ Net-_U5-Pad2_ d_inverter
U2 Net-_U1-Pad1_ Net-_U2-Pad2_ d_inverter
U3 Net-_U1-Pad2_ Net-_U3-Pad2_ d_inverter
U6 Net-_U2-Pad2_ Net-_U3-Pad2_ Net-_U33-Pad2_ d_and
U8 Net-_U10-Pad2_ Net-_U11-Pad2_ d_inverter
U7 Net-_U4-Pad2_ Net-_U5-Pad2_ Net-_U10-Pad2_ d_and
U9 Net-_U21-Pad5_ Net-_U11-Pad2_ Net-_U17-Pad1_ d_and
U10 Net-_U1-Pad14_ Net-_U10-Pad2_ Net-_U10-Pad3_ d_and
U21 Net-_U17-Pad3_ Net-_U1-Pad7_ Net-_U21-Pad3_ Net-_U1-Pad15_ Net-_U21-Pad5_ Net-_U21-Pad6_ d_dff
U25 Net-_U21-Pad3_ d_pulldown
U17 Net-_U17-Pad1_ Net-_U10-Pad3_ Net-_U17-Pad3_ d_or
U27 Net-_U23-Pad3_ d_pulldown
U30 Net-_U22-Pad6_ Net-_U30-Pad2_ d_inverter
U29 Net-_U21-Pad6_ Net-_U29-Pad2_ d_inverter
U33 Net-_U29-Pad2_ Net-_U33-Pad2_ Net-_U1-Pad3_ d_tristate
U34 Net-_U30-Pad2_ Net-_U33-Pad2_ Net-_U1-Pad4_ d_tristate
U26 Net-_U22-Pad3_ d_pulldown
U14 Net-_U1-Pad12_ Net-_U10-Pad2_ Net-_U14-Pad3_ d_and
U20 Net-_U15-Pad3_ Net-_U16-Pad3_ Net-_U20-Pad3_ d_or
U16 Net-_U1-Pad11_ Net-_U10-Pad2_ Net-_U16-Pad3_ d_and
U15 Net-_U15-Pad1_ Net-_U11-Pad2_ Net-_U15-Pad3_ d_and
U19 Net-_U13-Pad3_ Net-_U14-Pad3_ Net-_U19-Pad3_ d_or
U11 Net-_U11-Pad1_ Net-_U11-Pad2_ Net-_U11-Pad3_ d_and
U12 Net-_U1-Pad13_ Net-_U10-Pad2_ Net-_U12-Pad3_ d_and
U13 Net-_U13-Pad1_ Net-_U11-Pad2_ Net-_U13-Pad3_ d_and
U22 Net-_U18-Pad3_ Net-_U1-Pad7_ Net-_U22-Pad3_ Net-_U1-Pad15_ Net-_U11-Pad1_ Net-_U22-Pad6_ d_dff
U18 Net-_U11-Pad3_ Net-_U12-Pad3_ Net-_U18-Pad3_ d_or
.end
