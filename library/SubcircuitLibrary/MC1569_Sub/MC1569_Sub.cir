.title KiCad schematic
R10 Net-_Q6-Pad1_ Net-_Q7-Pad3_ 32k
Q7 Net-_Q7-Pad1_ Net-_Q14-Pad2_ Net-_Q7-Pad3_ eSim_NPN
R11 Net-_Q7-Pad1_ Net-_Q12-Pad1_ 1.03k
Q9 Net-_D5-Pad1_ Net-_Q7-Pad3_ Net-_Q7-Pad1_ eSim_PNP
D5 Net-_D5-Pad1_ Net-_D5-Pad2_ eSim_Diode
Q8 Net-_Q10-Pad1_ Net-_Q8-Pad2_ Net-_Q10-Pad2_ eSim_NPN
Q15 Net-_D5-Pad2_ Net-_Q15-Pad2_ Net-_Q13-Pad2_ eSim_NPN
Q11 Net-_Q10-Pad3_ Net-_Q11-Pad2_ Net-_Q11-Pad3_ eSim_NPN
Q13 Net-_D5-Pad2_ Net-_Q13-Pad2_ Net-_Q10-Pad3_ eSim_NPN
Q10 Net-_Q10-Pad1_ Net-_Q10-Pad2_ Net-_Q10-Pad3_ eSim_NPN
Q14 Net-_Q14-Pad1_ Net-_Q14-Pad2_ Net-_Q14-Pad3_ eSim_NPN
R14 Net-_Q14-Pad1_ Net-_Q12-Pad1_ 514
Q16 Net-_D5-Pad1_ Net-_Q16-Pad2_ Net-_Q16-Pad3_ eSim_NPN
Q12 Net-_Q12-Pad1_ Net-_D5-Pad1_ Net-_Q10-Pad1_ eSim_NPN
R13 Net-_Q6-Pad1_ Net-_Q14-Pad3_ 1.6k
R15 Net-_Q18-Pad2_ Net-_Q16-Pad2_ 1.0k
Q17 Net-_Q17-Pad1_ Net-_Q14-Pad3_ Net-_Q14-Pad1_ eSim_PNP
Q18 Net-_Q18-Pad1_ Net-_Q18-Pad2_ Net-_Q18-Pad3_ eSim_NPN
D3 Net-_D3-Pad1_ Net-_D3-Pad2_ eSim_Diode
R6 Net-_Q1-Pad3_ Net-_D4-Pad2_ 700
D4 Net-_D3-Pad2_ Net-_D4-Pad2_ eSim_Diode
Q5 Net-_Q10-Pad1_ Net-_D3-Pad1_ Net-_Q11-Pad2_ eSim_NPN
Q6 Net-_Q6-Pad1_ Net-_Q11-Pad2_ Net-_Q6-Pad3_ eSim_NPN
R9 Net-_Q1-Pad3_ Net-_Q6-Pad3_ 623
R12 Net-_Q1-Pad3_ Net-_Q11-Pad3_ 834
Q20 Net-_Q12-Pad1_ Net-_Q17-Pad1_ Net-_Q18-Pad1_ eSim_NPN
U1 Net-_Q22-Pad3_ Net-_D1-Pad1_ Net-_Q12-Pad1_ Net-_Q17-Pad1_ Net-_Q16-Pad3_ Net-_Q18-Pad2_ Net-_R16-Pad1_ Net-_Q15-Pad2_ Net-_Q10-Pad1_ Net-_Q1-Pad3_ PORT
Q22 Net-_Q12-Pad1_ Net-_Q18-Pad1_ Net-_Q22-Pad3_ eSim_NPN
Q21 Net-_Q17-Pad1_ Net-_Q16-Pad3_ Net-_Q18-Pad3_ eSim_NPN
R16 Net-_R16-Pad1_ Net-_D5-Pad2_ 50
R17 Net-_Q1-Pad3_ Net-_Q19-Pad3_ 410
Q19 Net-_Q18-Pad3_ Net-_Q11-Pad2_ Net-_Q19-Pad3_ eSim_NPN
R8 Net-_Q14-Pad2_ Net-_Q12-Pad1_ 834
Q4 Net-_Q2-Pad3_ Net-_Q14-Pad2_ Net-_Q2-Pad2_ eSim_NPN
R3 Net-_Q2-Pad3_ Net-_Q12-Pad1_ 514
Q1 Net-_D2-Pad2_ Net-_D1-Pad2_ Net-_Q1-Pad3_ eSim_NPN
U3 Net-_Q1-Pad3_ Net-_D2-Pad2_ zener
R2 Net-_Q1-Pad3_ Net-_D1-Pad2_ 5.0k
R5 Net-_D3-Pad1_ Net-_Q8-Pad2_ 2.67k
R4 Net-_Q8-Pad2_ Net-_Q3-Pad3_ 4.63k
R7 Net-_Q6-Pad1_ Net-_Q2-Pad2_ 1.6k
Q3 Net-_Q14-Pad2_ Net-_D2-Pad2_ Net-_Q3-Pad3_ eSim_NPN
R1 Net-_D2-Pad1_ Net-_Q12-Pad1_ 60k
D2 Net-_D2-Pad1_ Net-_D2-Pad2_ eSim_Diode
Q2 Net-_D2-Pad2_ Net-_Q2-Pad2_ Net-_Q2-Pad3_ eSim_PNP
U2 Net-_Q1-Pad3_ Net-_D2-Pad1_ zener
D1 Net-_D1-Pad1_ Net-_D1-Pad2_ eSim_Diode
.end
