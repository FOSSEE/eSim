.title KiCad schematic
U10 Net-_U10-Pad1_ Net-_U10-Pad2_ d_inverter
U7 Net-_U7-Pad1_ Net-_U12-Pad4_ d_inverter
U11 Net-_U11-Pad1_ Net-_U1-Pad8_ d_buffer
U9 Net-_U4-Pad2_ Net-_U5-Pad2_ Net-_U7-Pad1_ d_nand
U8 Net-_U12-Pad1_ Net-_U6-Pad2_ unconnected-_U8-Pad3_ Net-_U12-Pad4_ Net-_U11-Pad1_ unconnected-_U8-Pad6_ d_tff
U14 Net-_U12-Pad1_ Net-_U12-Pad5_ unconnected-_U14-Pad3_ Net-_U12-Pad4_ Net-_U14-Pad5_ unconnected-_U14-Pad6_ d_tff
U16 Net-_U12-Pad1_ Net-_U14-Pad5_ unconnected-_U16-Pad3_ Net-_U12-Pad4_ Net-_U16-Pad5_ unconnected-_U16-Pad6_ d_tff
U1 Net-_U1-Pad1_ Net-_U1-Pad2_ Net-_U1-Pad3_ unconnected-_U1-Pad4_ Net-_U12-Pad1_ unconnected-_U1-Pad6_ unconnected-_U1-Pad7_ Net-_U1-Pad8_ Net-_U1-Pad9_ Net-_U1-Pad10_ Net-_U1-Pad11_ unconnected-_U1-Pad12_ Net-_U1-Pad13_ unconnected-_U1-Pad14_ PORT
U15 Net-_U14-Pad5_ Net-_U1-Pad10_ d_buffer
U17 Net-_U16-Pad5_ Net-_U1-Pad11_ d_buffer
U12 Net-_U12-Pad1_ Net-_U10-Pad2_ unconnected-_U12-Pad3_ Net-_U12-Pad4_ Net-_U12-Pad5_ unconnected-_U12-Pad6_ d_tff
U13 Net-_U12-Pad5_ Net-_U1-Pad9_ d_buffer
U5 Net-_U1-Pad3_ Net-_U5-Pad2_ d_buffer
U4 Net-_U1-Pad2_ Net-_U4-Pad2_ d_buffer
U6 Net-_U2-Pad2_ Net-_U6-Pad2_ d_inverter
U3 Net-_U1-Pad1_ Net-_U10-Pad1_ d_buffer
U2 Net-_U1-Pad13_ Net-_U2-Pad2_ d_buffer
.end
