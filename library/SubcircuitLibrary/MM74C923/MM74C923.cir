.title KiCad schematic
U1 Y1 Y2 Y3 Y4 Y5 clk unconnected-_U1-Pad7_ X4 X3 unconnected-_U1-Pad10_ X2 X1 data_available Net-_U1-Pad14_ Net-_U1-Pad15_ Net-_U1-Pad16_ Net-_U1-Pad17_ Net-_U1-Pad18_ Net-_U1-Pad19_ unconnected-_U1-Pad20_ PORT
U17 Net-_U16-Pad3_ X2 d_inverter
U6 Net-_U2-Pad1_ Net-_U18-Pad2_ Net-_U6-Pad3_ d_and
U16 Net-_U16-Pad1_ Net-_U15-Pad5_ Net-_U16-Pad3_ d_and
U8 Net-_U6-Pad3_ X3 d_inverter
U10 Y3 d_pullup
U13 Y1 d_pullup
U14 Y2 d_pullup
U5 Net-_U4-Pad2_ Net-_U15-Pad1_ d_inverter
U9 GND Net-_U15-Pad3_ adc_bridge_1
U4 GND Net-_U4-Pad2_ adc_bridge_1
U15 Net-_U15-Pad1_ Net-_U15-Pad2_ Net-_U15-Pad3_ Net-_U15-Pad4_ Net-_U15-Pad5_ unconnected-_U15-Pad6_ d_tff
U7 GND Net-_U15-Pad4_ adc_bridge_1
U21 Net-_U15-Pad5_ Net-_U15-Pad2_ Net-_U15-Pad3_ Net-_U15-Pad4_ Net-_U2-Pad1_ unconnected-_U21-Pad6_ d_tff
U40 GND Net-_U40-Pad2_ adc_bridge_1
U18 Net-_U15-Pad5_ Net-_U18-Pad2_ d_inverter
U19 Net-_U16-Pad1_ Net-_U18-Pad2_ Net-_U19-Pad3_ d_and
U20 Net-_U19-Pad3_ X1 d_inverter
U3 Net-_U2-Pad3_ X4 d_inverter
U2 Net-_U2-Pad1_ Net-_U15-Pad5_ Net-_U2-Pad3_ d_and
U24 Y3 Net-_U24-Pad2_ Net-_U23-Pad2_ d_and
U25 Y4 Y5 Net-_U24-Pad2_ d_and
U31 Y5 Net-_U31-Pad2_ d_inverter
U22 Y1 Net-_U22-Pad2_ Net-_U22-Pad3_ d_and
U23 Y2 Net-_U23-Pad2_ Net-_U22-Pad2_ d_and
U12 Y5 d_pullup
U11 Y4 d_pullup
U46 Net-_U38-Pad3_ Net-_U41-Pad2_ Net-_U40-Pad2_ Net-_U42-Pad2_ Net-_U46-Pad5_ unconnected-_U46-Pad6_ d_dff
U45 Net-_U39-Pad3_ Net-_U41-Pad2_ Net-_U40-Pad2_ Net-_U42-Pad2_ Net-_U45-Pad5_ unconnected-_U45-Pad6_ d_dff
U53 Net-_U47-Pad5_ Net-_U48-Pad2_ Net-_U1-Pad15_ d_and
U58 Net-_U1-Pad15_ E dac_bridge_1
U35 clk Net-_U32-Pad2_ adc_bridge_1
U32 Net-_U22-Pad3_ Net-_U32-Pad2_ Net-_U15-Pad2_ d_and
U26 Net-_U2-Pad1_ Net-_U16-Pad1_ d_inverter
U37 Net-_U22-Pad3_ data_available dac_bridge_1
U43 Net-_U15-Pad5_ Net-_U41-Pad2_ Net-_U40-Pad2_ Net-_U42-Pad2_ Net-_U43-Pad5_ unconnected-_U43-Pad6_ d_dff
U44 Net-_U2-Pad1_ Net-_U41-Pad2_ Net-_U40-Pad2_ Net-_U42-Pad2_ Net-_U44-Pad5_ unconnected-_U44-Pad6_ d_dff
U28 Y2 Net-_U28-Pad2_ d_inverter
U27 Y1 unconnected-_U27-Pad2_ d_inverter
U30 Y4 Net-_U30-Pad2_ d_inverter
U29 Y3 Net-_U29-Pad2_ d_inverter
U33 Net-_U28-Pad2_ Y3 Net-_U33-Pad3_ d_and
U36 Net-_U33-Pad3_ Net-_U30-Pad2_ Net-_U36-Pad3_ d_or
U34 Net-_U29-Pad2_ Net-_U30-Pad2_ Net-_U34-Pad3_ d_or
U38 Net-_U34-Pad3_ Y5 Net-_U38-Pad3_ d_and
U39 Net-_U36-Pad3_ Y5 Net-_U39-Pad3_ d_and
U48 Net-_U1-Pad14_ Net-_U48-Pad2_ d_inverter
U47 Net-_U31-Pad2_ Net-_U41-Pad2_ Net-_U40-Pad2_ Net-_U42-Pad2_ Net-_U47-Pad5_ unconnected-_U47-Pad6_ d_dff
U42 GND Net-_U42-Pad2_ adc_bridge_1
U41 Net-_U22-Pad3_ Net-_U41-Pad2_ d_inverter
U50 Net-_U43-Pad5_ Net-_U48-Pad2_ Net-_U1-Pad19_ d_and
U51 Net-_U44-Pad5_ Net-_U48-Pad2_ Net-_U1-Pad18_ d_and
U54 Net-_U1-Pad19_ A dac_bridge_1
U56 Net-_U1-Pad18_ B dac_bridge_1
U57 Net-_U1-Pad16_ D dac_bridge_1
U52 Net-_U46-Pad5_ Net-_U48-Pad2_ Net-_U1-Pad16_ d_and
U49 Net-_U45-Pad5_ Net-_U48-Pad2_ Net-_U1-Pad17_ d_and
U55 Net-_U1-Pad17_ C dac_bridge_1
.end
