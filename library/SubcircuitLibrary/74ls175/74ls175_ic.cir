.title KiCad schematic
U5 Net-_U1-Pad12_ Net-_U1-Pad9_ Net-_U5-Pad3_ Net-_U1-Pad1_ Net-_U1-Pad10_ Net-_U1-Pad11_ d_dff
U1 Net-_U1-Pad1_ Net-_U1-Pad2_ Net-_U1-Pad3_ Net-_U1-Pad4_ Net-_U1-Pad5_ Net-_U1-Pad6_ Net-_U1-Pad7_ unconnected-_U1-Pad8_ Net-_U1-Pad9_ Net-_U1-Pad10_ Net-_U1-Pad11_ Net-_U1-Pad12_ Net-_U1-Pad13_ Net-_U1-Pad14_ Net-_U1-Pad15_ unconnected-_U1-Pad16_ PORT
U3 Net-_U1-Pad4_ Net-_U1-Pad9_ Net-_U3-Pad3_ Net-_U1-Pad1_ Net-_U1-Pad2_ Net-_U1-Pad3_ d_dff
U9 Net-_U5-Pad3_ d_pulldown
U4 Net-_U1-Pad5_ Net-_U1-Pad9_ Net-_U4-Pad3_ Net-_U1-Pad1_ Net-_U1-Pad7_ Net-_U1-Pad6_ d_dff
U7 Net-_U3-Pad3_ d_pulldown
U8 Net-_U4-Pad3_ d_pulldown
U2 Net-_U1-Pad1_ d_pulldown
U6 Net-_U1-Pad13_ Net-_U1-Pad9_ Net-_U10-Pad1_ Net-_U1-Pad1_ Net-_U1-Pad15_ Net-_U1-Pad14_ d_dff
U10 Net-_U10-Pad1_ d_pulldown
.end
