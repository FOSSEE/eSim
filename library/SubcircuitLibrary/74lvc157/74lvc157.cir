.title KiCad schematic
U8 out plot_v1
R1 out GND 1k
X1 Net-_U4-Pad2_ Net-_U5-Pad2_ Net-_U6-Pad2_ Net-_U7-Pad1_ unconnected-_X1-Pad5_ unconnected-_X1-Pad6_ unconnected-_X1-Pad7_ unconnected-_X1-Pad8_ unconnected-_X1-Pad9_ unconnected-_X1-Pad10_ unconnected-_X1-Pad11_ unconnected-_X1-Pad12_ unconnected-_X1-Pad13_ unconnected-_X1-Pad14_ Net-_U9-Pad2_ unconnected-_X1-Pad16_ 74lvc157
U9 Net-_U9-Pad1_ Net-_U9-Pad2_ adc_bridge_1
v4 Net-_U9-Pad1_ GND 0
U7 Net-_U7-Pad1_ out dac_bridge_1
v2 A GND pulse(5 0 0 1n 1n 2m 4m)
v1 ab GND pulse(0 5 0 1n 1n 5m 10m)
U2 A plot_v1
v3 B GND pulse(0 5 0 1n 1n 2m 4m)
U1 ab plot_v1
U4 ab Net-_U4-Pad2_ adc_bridge_1
U3 B plot_v1
U6 B Net-_U6-Pad2_ adc_bridge_1
U5 A Net-_U5-Pad2_ adc_bridge_1
.end
