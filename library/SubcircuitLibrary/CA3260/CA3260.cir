.title KiCad schematic
M4 Net-_D2-Pad2_ Net-_M1-Pad1_ Net-_M1-Pad3_ Net-_M1-Pad3_ eSim_MOS_P
D4 Net-_D3-Pad1_ Net-_D4-Pad2_ eSim_Diode
R7 Net-_C1-Pad1_ Net-_M6-Pad1_ 2k
D3 Net-_D3-Pad1_ Net-_D2-Pad2_ eSim_Diode
M6 Net-_M6-Pad1_ Net-_M1-Pad1_ Net-_M1-Pad3_ Net-_M1-Pad3_ eSim_MOS_P
R5 Net-_C1-Pad2_ Net-_M5-Pad1_ 1k
Q5 Net-_C1-Pad2_ Net-_M3-Pad1_ Net-_Q5-Pad3_ eSim_NPN
M5 Net-_M5-Pad1_ Net-_D4-Pad2_ Net-_D2-Pad2_ Net-_D2-Pad2_ eSim_MOS_P
C1 Net-_C1-Pad1_ Net-_C1-Pad2_ 30p
R3 Net-_Q4-Pad1_ Net-_M3-Pad1_ 1k
M3 Net-_M3-Pad1_ Net-_D1-Pad2_ Net-_D2-Pad2_ Net-_D2-Pad2_ eSim_MOS_P
R6 Net-_M7-Pad3_ Net-_Q5-Pad3_ 1k
U1 Net-_M7-Pad1_ Net-_D4-Pad2_ Net-_D1-Pad2_ Net-_M10-Pad3_ Net-_D8-Pad2_ Net-_D5-Pad2_ Net-_M10-Pad1_ Net-_M1-Pad3_ PORT
D2 Net-_D1-Pad1_ Net-_D2-Pad2_ eSim_Diode
M2 Net-_M2-Pad1_ Net-_M1-Pad1_ Net-_M1-Pad3_ Net-_M1-Pad3_ eSim_MOS_P
D1 Net-_D1-Pad1_ Net-_D1-Pad2_ eSim_Diode
M1 Net-_M1-Pad1_ Net-_M1-Pad1_ Net-_M1-Pad3_ Net-_M1-Pad3_ eSim_MOS_P
Q1 Net-_M1-Pad3_ Net-_M1-Pad1_ Net-_Q1-Pad3_ eSim_NPN
Q3 Net-_M2-Pad1_ Net-_M2-Pad1_ Net-_M7-Pad3_ eSim_NPN
Q2 Net-_M1-Pad1_ Net-_M2-Pad1_ Net-_Q2-Pad3_ eSim_NPN
R1 Net-_M7-Pad3_ Net-_Q1-Pad3_ 200k
R2 Net-_M7-Pad3_ Net-_Q2-Pad3_ 300k
Q4 Net-_Q4-Pad1_ Net-_M3-Pad1_ Net-_Q4-Pad3_ eSim_NPN
R4 Net-_M7-Pad3_ Net-_Q4-Pad3_ 1k
Q6 Net-_M6-Pad1_ Net-_C1-Pad2_ Net-_M7-Pad3_ eSim_NPN
M7 Net-_M7-Pad1_ Net-_M6-Pad1_ Net-_M7-Pad3_ Net-_M7-Pad3_ eSim_MOS_N
M10 Net-_M10-Pad1_ Net-_M10-Pad2_ Net-_M10-Pad3_ Net-_M10-Pad3_ eSim_MOS_N
M9 Net-_M10-Pad1_ Net-_M10-Pad2_ Net-_M1-Pad3_ Net-_M1-Pad3_ eSim_MOS_P
M8 Net-_M7-Pad1_ Net-_M6-Pad1_ Net-_M1-Pad3_ Net-_M1-Pad3_ eSim_MOS_P
M11 Net-_M10-Pad2_ Net-_M11-Pad2_ Net-_M1-Pad3_ Net-_M1-Pad3_ eSim_MOS_P
R8 Net-_C2-Pad1_ Net-_M10-Pad2_ 2k
D5 Net-_D5-Pad1_ Net-_D5-Pad2_ eSim_Diode
C2 Net-_C2-Pad1_ Net-_C2-Pad2_ 30p
Q7 Net-_M10-Pad2_ Net-_C2-Pad2_ Net-_M10-Pad3_ eSim_NPN
M13 Net-_D6-Pad2_ Net-_M11-Pad2_ Net-_M1-Pad3_ Net-_M1-Pad3_ eSim_MOS_P
D6 Net-_D5-Pad1_ Net-_D6-Pad2_ eSim_Diode
Q8 Net-_C2-Pad2_ Net-_M14-Pad1_ Net-_Q8-Pad3_ eSim_NPN
R10 Net-_M10-Pad3_ Net-_Q8-Pad3_ 1k
R11 Net-_Q9-Pad1_ Net-_M14-Pad1_ 1k
Q9 Net-_Q9-Pad1_ Net-_M14-Pad1_ Net-_Q9-Pad3_ eSim_NPN
M12 Net-_M12-Pad1_ Net-_D5-Pad2_ Net-_D6-Pad2_ Net-_D6-Pad2_ eSim_MOS_P
R9 Net-_C2-Pad2_ Net-_M12-Pad1_ 1k
M14 Net-_M14-Pad1_ Net-_D8-Pad2_ Net-_D6-Pad2_ Net-_D6-Pad2_ eSim_MOS_P
R13 Net-_M10-Pad3_ Net-_Q11-Pad3_ 300k
R14 Net-_M10-Pad3_ Net-_Q12-Pad3_ 200k
R12 Net-_M10-Pad3_ Net-_Q9-Pad3_ 1k
M16 Net-_M11-Pad2_ Net-_M11-Pad2_ Net-_M1-Pad3_ Net-_M1-Pad3_ eSim_MOS_P
D7 Net-_D7-Pad1_ Net-_D6-Pad2_ eSim_Diode
M15 Net-_M15-Pad1_ Net-_M11-Pad2_ Net-_M1-Pad3_ Net-_M1-Pad3_ eSim_MOS_P
D8 Net-_D7-Pad1_ Net-_D8-Pad2_ eSim_Diode
Q10 Net-_M15-Pad1_ Net-_M15-Pad1_ Net-_M10-Pad3_ eSim_NPN
Q12 Net-_M1-Pad3_ Net-_M11-Pad2_ Net-_Q12-Pad3_ eSim_NPN
Q11 Net-_M11-Pad2_ Net-_M15-Pad1_ Net-_Q11-Pad3_ eSim_NPN
.end
