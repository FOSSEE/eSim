.title KiCad schematic
R3 Net-_Q3-Pad2_ Net-_D1-Pad1_ 1k
D2 Net-_D2-Pad1_ Net-_D2-Pad2_ eSim_Diode
R4 Net-_R1-Pad1_ Net-_D2-Pad1_ 1.4k
Q1 Net-_Q1-Pad1_ Net-_Q1-Pad2_ Net-_D1-Pad2_ eSim_NPN
R1 Net-_R1-Pad1_ Net-_Q1-Pad2_ 6k
U1 Net-_D1-Pad2_ Net-_Q5-Pad1_ Net-_R1-Pad1_ Net-_D1-Pad1_ PORT
D1 Net-_D1-Pad1_ Net-_D1-Pad2_ eSim_Diode
Q3 Net-_Q3-Pad1_ Net-_Q3-Pad2_ Net-_D1-Pad1_ eSim_NPN
R5 Net-_D2-Pad1_ Net-_Q3-Pad1_ 2k
Q2 Net-_D2-Pad2_ Net-_Q1-Pad1_ Net-_Q2-Pad3_ eSim_NPN
R2 Net-_Q2-Pad3_ Net-_Q3-Pad2_ 100
R6 Net-_R1-Pad1_ Net-_Q4-Pad1_ 1.6k
Q5 Net-_Q5-Pad1_ Net-_Q4-Pad1_ Net-_D1-Pad1_ eSim_NPN
Q4 Net-_Q4-Pad1_ Net-_Q3-Pad1_ Net-_D1-Pad1_ eSim_NPN
.end
