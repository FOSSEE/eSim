* C:\FOSSEE\eSim\library\SubcircuitLibrary\IC_MC1556\IC_MC1556.cir

* EESchema Netlist Version 1.1 (Spice format) creation date: 04/19/26 13:16:21

* To exclude a component from the Spice Netlist add [Spice_Netlist_Enabled] user FIELD set to: N
* To reorder the component spice node sequence add [Spice_Node_Sequence] user FIELD and define sequence: 2,1,0

* Sheet Name: /
Q1  Net-_Q1-Pad1_ Net-_Q1-Pad2_ Net-_Q1-Pad3_ eSim_NPN
Q3  Net-_Q3-Pad1_ Net-_Q1-Pad3_ Net-_Q3-Pad3_ eSim_PNP
R3  Net-_Q1-Pad1_ Net-_Q3-Pad3_ 1.5k
Q2  Net-_Q1-Pad3_ Net-_D4-Pad1_ Net-_Q2-Pad3_ eSim_NPN
R2  Net-_D1-Pad2_ Net-_Q1-Pad1_ 500
Q7  Net-_Q7-Pad1_ Net-_Q10-Pad3_ Net-_Q7-Pad3_ eSim_PNP
R8  Net-_Q10-Pad1_ Net-_Q7-Pad3_ 1.5k
R7  Net-_D1-Pad2_ Net-_Q10-Pad1_ 500
Q10  Net-_Q10-Pad1_ Net-_D1-Pad2_ Net-_Q10-Pad3_ eSim_PNP
Q6  Net-_Q18-Pad1_ Net-_Q3-Pad1_ Net-_Q4-Pad2_ eSim_NPN
Q4  Net-_Q3-Pad1_ Net-_Q4-Pad2_ Net-_D4-Pad2_ eSim_PNP
R4  Net-_D4-Pad2_ Net-_D4-Pad2_ 1k
R1  Net-_Q2-Pad3_ Net-_D4-Pad2_ 7.7k
D1  Net-_D1-Pad1_ Net-_D1-Pad2_ eSim_Diode
D2  Net-_D1-Pad1_ Net-_D1-Pad2_ eSim_Diode
Q5  Net-_D1-Pad1_ Net-_D3-Pad2_ Net-_Q5-Pad3_ eSim_PNP
R5  Net-_Q18-Pad1_ Net-_Q5-Pad3_ 4k
D3  Net-_D3-Pad1_ Net-_D3-Pad2_ eSim_Diode
R11  Net-_Q18-Pad1_ Net-_D3-Pad1_ 1k
R6  Net-_Q4-Pad2_ Net-_D4-Pad2_ 39k
Q8  Net-_Q7-Pad1_ Net-_Q4-Pad2_ Net-_D4-Pad2_ eSim_NPN
R9  Net-_D4-Pad2_ Net-_D4-Pad2_ 1k
R10  Net-_Q9-Pad3_ Net-_D4-Pad2_ 7.7k
Q9  Net-_Q10-Pad3_ Net-_D4-Pad1_ Net-_Q9-Pad3_ eSim_NPN
R12  Net-_D3-Pad2_ Net-_D4-Pad1_ 56k
D4  Net-_D4-Pad1_ Net-_D4-Pad2_ eSim_Diode
Q11  Net-_C1-Pad2_ Net-_Q11-Pad2_ Net-_D4-Pad2_ eSim_PNP
C1  Net-_C1-Pad1_ Net-_C1-Pad2_ 35pf
Q12  Net-_C1-Pad1_ Net-_C1-Pad2_ Net-_Q12-Pad3_ eSim_NPN
Q16  Net-_Q15-Pad3_ Net-_Q12-Pad3_ Net-_Q11-Pad2_ eSim_NPN
R13  Net-_Q12-Pad3_ Net-_D4-Pad2_ 39k
R16  Net-_Q11-Pad2_ Net-_D4-Pad2_ 50
Q15  Net-_D5-Pad1_ Net-_D5-Pad2_ Net-_Q15-Pad3_ eSim_NPN
Q17  Net-_D4-Pad2_ Net-_Q15-Pad3_ Net-_Q17-Pad3_ eSim_PNP
Q19  Net-_D4-Pad2_ Net-_Q17-Pad3_ Net-_Q19-Pad3_ eSim_PNP
D6  Net-_D5-Pad1_ Net-_D6-Pad2_ eSim_Diode
D7  Net-_D6-Pad2_ Net-_D5-Pad1_ eSim_Diode
R18  Net-_D6-Pad2_ Net-_Q19-Pad3_ 50
R17  Net-_Q18-Pad3_ Net-_D6-Pad2_ 30
D5  Net-_D5-Pad1_ Net-_D5-Pad2_ eSim_Diode
Q18  Net-_Q18-Pad1_ Net-_Q14-Pad1_ Net-_Q18-Pad3_ eSim_NPN
Q14  Net-_Q14-Pad1_ Net-_C1-Pad1_ Net-_D5-Pad1_ eSim_NPN
R15  Net-_C1-Pad1_ Net-_Q14-Pad1_ 7.7k
Q13  Net-_C1-Pad1_ Net-_D3-Pad2_ Net-_Q13-Pad3_ eSim_PNP
R14  Net-_Q18-Pad1_ Net-_Q13-Pad3_ 1k
U1  Net-_D4-Pad2_ Net-_D1-Pad2_ Net-_Q1-Pad2_ Net-_D4-Pad2_ Net-_D4-Pad2_ Net-_D6-Pad2_ Net-_Q18-Pad1_ ? PORT

.end
