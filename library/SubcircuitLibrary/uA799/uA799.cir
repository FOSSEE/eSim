.title KiCad schematic
Q6 Net-_Q1-Pad2_ Net-_Q1-Pad2_ Net-_J1-Pad2_ eSim_NPN
Q8 Net-_C1-Pad2_ Net-_Q1-Pad2_ Net-_Q8-Pad3_ eSim_NPN
Q7 Net-_C1-Pad2_ Net-_Q1-Pad2_ Net-_J1-Pad2_ eSim_NPN
U1 Net-_Q5-Pad3_ Net-_Q2-Pad2_ Net-_Q14-Pad2_ Net-_J1-Pad2_ Net-_Q8-Pad3_ Net-_Q26-Pad3_ Net-_J1-Pad1_ unconnected-_U1-Pad8_ PORT
Q14 Net-_J1-Pad2_ Net-_Q14-Pad2_ Net-_Q10-Pad2_ eSim_PNP
Q15 Net-_J1-Pad2_ Net-_C1-Pad2_ Net-_Q13-Pad1_ eSim_PNP
Q17 Net-_Q16-Pad1_ Net-_Q12-Pad2_ Net-_J1-Pad1_ eSim_PNP
Q1 Net-_J1-Pad2_ Net-_Q1-Pad2_ Net-_Q1-Pad3_ eSim_PNP
Q5 Net-_Q1-Pad2_ Net-_Q1-Pad2_ Net-_Q5-Pad3_ eSim_NPN
Q2 Net-_J1-Pad2_ Net-_Q2-Pad2_ Net-_Q2-Pad3_ eSim_PNP
Q4 Net-_Q1-Pad2_ Net-_Q2-Pad3_ Net-_Q10-Pad3_ eSim_PNP
Q3 Net-_Q2-Pad3_ Net-_Q2-Pad3_ Net-_Q10-Pad3_ eSim_PNP
Q13 Net-_Q13-Pad1_ Net-_Q12-Pad2_ Net-_Q12-Pad3_ eSim_PNP
Q12 Net-_Q10-Pad3_ Net-_Q12-Pad2_ Net-_Q12-Pad3_ eSim_PNP
Q9 Net-_Q1-Pad3_ Net-_Q12-Pad2_ Net-_Q12-Pad3_ eSim_PNP
Q10 Net-_C1-Pad2_ Net-_Q10-Pad2_ Net-_Q10-Pad3_ eSim_PNP
Q11 Net-_Q10-Pad2_ Net-_Q10-Pad2_ Net-_Q10-Pad3_ eSim_PNP
R1 Net-_Q12-Pad3_ Net-_J1-Pad1_ 1k
U2 Net-_J1-Pad2_ Net-_Q16-Pad1_ zener
C1 Net-_C1-Pad1_ Net-_C1-Pad2_ 5p
J1 Net-_J1-Pad1_ Net-_J1-Pad2_ Net-_J1-Pad3_ jfet_n
Q28 Net-_Q12-Pad2_ Net-_J1-Pad3_ Net-_Q28-Pad3_ eSim_NPN
Q29 Net-_J1-Pad3_ Net-_Q28-Pad3_ Net-_J1-Pad2_ eSim_NPN
R6 Net-_Q28-Pad3_ Net-_J1-Pad2_ 3k
Q20 Net-_Q20-Pad1_ Net-_Q20-Pad2_ Net-_J1-Pad2_ eSim_NPN
Q24 Net-_C1-Pad1_ Net-_Q24-Pad2_ Net-_J1-Pad2_ eSim_NPN
Q25 Net-_J1-Pad1_ Net-_C1-Pad1_ Net-_Q25-Pad3_ eSim_NPN
R4 Net-_Q19-Pad3_ Net-_Q20-Pad1_ 50k
Q22 Net-_C1-Pad1_ Net-_Q19-Pad3_ Net-_Q20-Pad1_ eSim_NPN
Q26 Net-_J1-Pad2_ Net-_Q20-Pad1_ Net-_Q26-Pad3_ eSim_PNP
R5 Net-_Q25-Pad3_ Net-_Q26-Pad3_ 20
Q27 Net-_C1-Pad1_ Net-_Q25-Pad3_ Net-_Q26-Pad3_ eSim_NPN
Q21 Net-_C1-Pad1_ Net-_Q12-Pad2_ Net-_J1-Pad1_ eSim_PNP
Q23 Net-_Q12-Pad2_ Net-_Q12-Pad2_ Net-_J1-Pad1_ eSim_PNP
Q18 Net-_C1-Pad1_ Net-_Q12-Pad2_ Net-_J1-Pad1_ eSim_PNP
R2 Net-_Q24-Pad2_ Net-_Q16-Pad3_ 1k
Q16 Net-_Q16-Pad1_ Net-_Q13-Pad1_ Net-_Q16-Pad3_ eSim_NPN
Q19 Net-_C1-Pad1_ Net-_C1-Pad1_ Net-_Q19-Pad3_ eSim_NPN
R3 Net-_Q20-Pad2_ Net-_Q16-Pad3_ 1k
.end
