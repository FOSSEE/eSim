.title KiCad schematic
U19 Net-_U10-Pad3_ Net-_U1-Pad17_ d_inverter
U20 Net-_U11-Pad3_ Net-_U1-Pad18_ d_inverter
U10 Net-_U1-Pad8_ Net-_U10-Pad2_ Net-_U10-Pad3_ d_tristate
U11 Net-_U1-Pad9_ Net-_U10-Pad2_ Net-_U11-Pad3_ d_tristate
U12 Net-_U12-Pad1_ Net-_U12-Pad2_ Net-_U10-Pad2_ d_and
U1 Net-_U1-Pad1_ Net-_U1-Pad2_ Net-_U1-Pad3_ Net-_U1-Pad4_ Net-_U1-Pad5_ Net-_U1-Pad6_ Net-_U1-Pad7_ Net-_U1-Pad8_ Net-_U1-Pad9_ unconnected-_U1-Pad10_ Net-_U1-Pad11_ Net-_U1-Pad12_ Net-_U1-Pad13_ Net-_U1-Pad14_ Net-_U1-Pad15_ Net-_U1-Pad16_ Net-_U1-Pad17_ Net-_U1-Pad18_ Net-_U1-Pad19_ unconnected-_U1-Pad20_ PORT
U3 Net-_U1-Pad19_ Net-_U12-Pad2_ d_inverter
U2 Net-_U1-Pad1_ Net-_U12-Pad1_ d_inverter
U7 Net-_U1-Pad5_ Net-_U10-Pad2_ Net-_U16-Pad1_ d_tristate
U6 Net-_U1-Pad4_ Net-_U10-Pad2_ Net-_U15-Pad1_ d_tristate
U4 Net-_U1-Pad2_ Net-_U10-Pad2_ Net-_U13-Pad1_ d_tristate
U8 Net-_U1-Pad6_ Net-_U10-Pad2_ Net-_U17-Pad1_ d_tristate
U5 Net-_U1-Pad3_ Net-_U10-Pad2_ Net-_U14-Pad1_ d_tristate
U13 Net-_U13-Pad1_ Net-_U1-Pad11_ d_inverter
U14 Net-_U14-Pad1_ Net-_U1-Pad12_ d_inverter
U18 Net-_U18-Pad1_ Net-_U1-Pad16_ d_inverter
U17 Net-_U17-Pad1_ Net-_U1-Pad15_ d_inverter
U9 Net-_U1-Pad7_ Net-_U10-Pad2_ Net-_U18-Pad1_ d_tristate
U16 Net-_U16-Pad1_ Net-_U1-Pad14_ d_inverter
U15 Net-_U15-Pad1_ Net-_U1-Pad13_ d_inverter
.end
