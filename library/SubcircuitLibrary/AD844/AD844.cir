.title KiCad schematic
QN9 Net-_QN11-Pad3_ Net-_QN6-Pad2_ Net-_I2-Pad1_ npn
QN11 Net-_I1-Pad2_ Z Net-_QN11-Pad3_ npn
QN8 Net-_QN6-Pad2_ Net-_QN6-Pad2_ Net-_I2-Pad1_ npn
QN7 Z Net-_QN5-Pad1_ Net-_QN6-Pad2_ npn
QP9 Net-_QN10-Pad2_ Net-_QP5-Pad2_ Net-_I1-Pad2_ pnp
R3 Y Z 5k
QP11 Net-_I2-Pad1_ Z Net-_QN10-Pad2_ pnp
QP7 Net-_QP5-Pad2_ Net-_QP5-Pad2_ Net-_I1-Pad2_ pnp
QP5 Net-_QP5-Pad1_ Net-_QP5-Pad2_ Net-_I1-Pad2_ pnp
QP8 Z Net-_QN4-Pad1_ Net-_QP5-Pad2_ pnp
QN4 Net-_QN4-Pad1_ Net-_I1-Pad1_ Net-_QN4-Pad3_ npn
QP6 Net-_QN4-Pad1_ Net-_QN4-Pad1_ Net-_QP5-Pad1_ pnp
U3 Net-_QN4-Pad3_ plot_v1
I2 Net-_I2-Pad1_ Net-_I2-Pad2_ dc
v2 Y Net-_I2-Pad1_ DC
QP3 Net-_I2-Pad2_ Net-_I2-Pad2_ Y pnp
QP12 Net-_I2-Pad1_ Net-_QN11-Pad3_ W pnp
QN10 Net-_I1-Pad2_ Net-_QN10-Pad2_ W npn
U2 W plot_v1
QP4 Net-_QN5-Pad1_ Net-_I2-Pad2_ Net-_QN4-Pad3_ pnp
R2 x Net-_QN4-Pad3_ 1k
QN6 Net-_QN5-Pad3_ Net-_QN6-Pad2_ Net-_I2-Pad1_ npn
QN5 Net-_QN5-Pad1_ Net-_QN5-Pad1_ Net-_QN5-Pad3_ npn
U1 x plot_v1
v3 x Y sine
I1 Net-_I1-Pad1_ Net-_I1-Pad2_ dc
v1 Net-_I1-Pad2_ Y DC
QN3 Net-_I1-Pad1_ Net-_I1-Pad1_ Y npn
.end
