.title KiCad schematic
Q3 Net-_Q3-Pad1_ Net-_Q1-Pad1_ Net-_D3-Pad2_ eSim_NPN
Q6 Net-_Q6-Pad1_ Net-_Q4-Pad1_ Net-_Q6-Pad3_ eSim_NPN
U1 Net-_Q1-Pad2_ Net-_R13-Pad1_ Net-_Q1-Pad1_ Net-_D2-Pad1_ Net-_R4-Pad2_ Net-_D2-Pad2_ Net-_Q4-Pad1_ Net-_Q6-Pad3_ Net-_D3-Pad1_ Net-_Q5-Pad1_ Net-_D1-Pad2_ Net-_Q1-Pad3_ PORT
R10 Net-_D1-Pad2_ Net-_Q6-Pad3_ 12k
D3 Net-_D3-Pad1_ Net-_D3-Pad2_ eSim_Diode
Q4 Net-_Q4-Pad1_ Net-_D3-Pad2_ Net-_Q4-Pad3_ eSim_NPN
R11 Net-_Q2-Pad2_ Net-_R11-Pad2_ 5k
R13 Net-_R13-Pad1_ Net-_R11-Pad2_ 5k
R5 Net-_D1-Pad2_ Net-_D3-Pad2_ 12k
Q5 Net-_Q5-Pad1_ Net-_Q5-Pad2_ Net-_D1-Pad2_ eSim_NPN
R7 Net-_Q4-Pad3_ Net-_Q5-Pad1_ 2.5k
R12 Net-_R11-Pad2_ Net-_Q5-Pad2_ 5k
R8 Net-_Q4-Pad1_ Net-_R4-Pad2_ 27k
R4 Net-_Q1-Pad1_ Net-_R4-Pad2_ 12k
R6 Net-_Q3-Pad1_ Net-_R4-Pad2_ 0.1k
D2 Net-_D2-Pad1_ Net-_D2-Pad2_ eSim_Diode
R9 Net-_Q6-Pad1_ Net-_R4-Pad2_ 0.3k
R1 Net-_R1-Pad1_ Net-_D1-Pad1_ 12k
R3 Net-_R1-Pad1_ Net-_Q1-Pad2_ 33k
R2 Net-_R1-Pad1_ Net-_Q1-Pad1_ 12k
D1 Net-_D1-Pad1_ Net-_D1-Pad2_ eSim_Diode
Q2 Net-_Q1-Pad3_ Net-_Q2-Pad2_ Net-_D1-Pad2_ eSim_NPN
Q1 Net-_Q1-Pad1_ Net-_Q1-Pad2_ Net-_Q1-Pad3_ eSim_NPN
.end
