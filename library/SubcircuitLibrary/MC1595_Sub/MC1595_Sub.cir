.title KiCad schematic
R5 Net-_R2-Pad1_ Net-_D3-Pad2_ 500
D3 Net-_D3-Pad1_ Net-_D3-Pad2_ eSim_Diode
R6 Net-_R2-Pad1_ Net-_D4-Pad2_ 500
D4 Net-_D4-Pad1_ Net-_D4-Pad2_ eSim_Diode
R3 Net-_R2-Pad1_ Net-_Q5-Pad3_ 500
Q10 Net-_Q10-Pad1_ Net-_D4-Pad1_ Net-_Q10-Pad3_ eSim_NPN
R8 Net-_R2-Pad1_ Net-_Q10-Pad3_ 500
R9 Net-_R2-Pad1_ Net-_Q12-Pad3_ 500
Q12 Net-_Q12-Pad1_ Net-_D4-Pad1_ Net-_Q12-Pad3_ eSim_NPN
Q9 Net-_Q11-Pad3_ Net-_Q8-Pad3_ Net-_Q10-Pad1_ eSim_NPN
R7 Net-_Q10-Pad1_ Net-_Q8-Pad3_ 4.0k
U1 Net-_D1-Pad1_ Net-_Q11-Pad1_ Net-_D3-Pad1_ Net-_Q1-Pad2_ Net-_Q2-Pad3_ Net-_Q4-Pad3_ Net-_R2-Pad1_ Net-_Q6-Pad2_ Net-_Q8-Pad2_ Net-_Q10-Pad1_ Net-_Q12-Pad1_ Net-_Q16-Pad2_ Net-_D4-Pad1_ Net-_Q13-Pad1_ PORT
R10 Net-_Q12-Pad1_ Net-_Q14-Pad2_ 4.0k
Q14 Net-_Q13-Pad3_ Net-_Q14-Pad2_ Net-_Q12-Pad1_ eSim_NPN
Q8 Net-_Q11-Pad3_ Net-_Q8-Pad2_ Net-_Q8-Pad3_ eSim_NPN
Q6 Net-_D2-Pad2_ Net-_Q6-Pad2_ Net-_Q4-Pad2_ eSim_NPN
D2 Net-_D1-Pad1_ Net-_D2-Pad2_ eSim_Diode
Q7 Net-_Q13-Pad1_ Net-_D2-Pad2_ Net-_Q11-Pad3_ eSim_NPN
Q11 Net-_Q11-Pad1_ Net-_D1-Pad2_ Net-_Q11-Pad3_ eSim_NPN
D1 Net-_D1-Pad1_ Net-_D1-Pad2_ eSim_Diode
Q16 Net-_Q13-Pad3_ Net-_Q16-Pad2_ Net-_Q14-Pad2_ eSim_NPN
Q13 Net-_Q13-Pad1_ Net-_D1-Pad2_ Net-_Q13-Pad3_ eSim_NPN
Q15 Net-_Q11-Pad1_ Net-_D2-Pad2_ Net-_Q13-Pad3_ eSim_NPN
Q3 Net-_Q2-Pad3_ Net-_D3-Pad1_ Net-_Q3-Pad3_ eSim_NPN
R2 Net-_R2-Pad1_ Net-_Q3-Pad3_ 500
Q4 Net-_D2-Pad2_ Net-_Q4-Pad2_ Net-_Q4-Pad3_ eSim_NPN
R4 Net-_Q4-Pad3_ Net-_Q4-Pad2_ 4.0k
Q5 Net-_Q4-Pad3_ Net-_D3-Pad1_ Net-_Q5-Pad3_ eSim_NPN
R1 Net-_Q2-Pad3_ Net-_Q1-Pad3_ 4.0k
Q2 Net-_D1-Pad2_ Net-_Q1-Pad3_ Net-_Q2-Pad3_ eSim_NPN
Q1 Net-_D1-Pad2_ Net-_Q1-Pad2_ Net-_Q1-Pad3_ eSim_NPN
.end
