.title KiCad schematic
D3 Net-_R2-Pad1_ Net-_Q4-Pad2_ eSim_Diode
Q4 Net-_R3-Pad1_ Net-_Q4-Pad2_ Net-_R5-Pad2_ eSim_NPN
R3 Net-_R3-Pad1_ Net-_R1-Pad2_ 1.6K
R12 Net-_R12-Pad1_ Net-_R1-Pad2_ 2K
Q5 Net-_Q4-Pad2_ Net-_R4-Pad2_ Net-_R4-Pad1_ eSim_NPN
R5 Net-_R4-Pad1_ Net-_R5-Pad2_ 1K
D9 Net-_R12-Pad1_ Net-_Q16-Pad1_ eSim_Diode
Q17 Net-_R13-Pad1_ Net-_Q16-Pad1_ Net-_R15-Pad2_ eSim_NPN
R13 Net-_R13-Pad1_ Net-_R1-Pad2_ 1.6K
R14 Net-_R4-Pad1_ Net-_R14-Pad2_ 800
D8 Net-_R4-Pad1_ Net-_Q14-Pad3_ eSim_Diode
Q15 Net-_R12-Pad1_ Net-_Q13-Pad1_ Net-_R14-Pad2_ eSim_NPN
Q16 Net-_Q16-Pad1_ Net-_R14-Pad2_ Net-_R4-Pad1_ eSim_NPN
U1 Net-_Q1-Pad3_ Net-_Q2-Pad3_ Net-_Q6-Pad1_ Net-_Q12-Pad3_ Net-_Q11-Pad3_ Net-_Q7-Pad1_ Net-_R4-Pad1_ Net-_Q18-Pad1_ Net-_Q13-Pad3_ Net-_Q14-Pad3_ Net-_Q19-Pad1_ Net-_Q24-Pad3_ Net-_Q23-Pad3_ Net-_R1-Pad2_ PORT
D7 Net-_R4-Pad1_ Net-_Q13-Pad3_ eSim_Diode
Q1 Net-_Q1-Pad1_ Net-_R1-Pad1_ Net-_Q1-Pad3_ eSim_NPN
R1 Net-_R1-Pad1_ Net-_R1-Pad2_ 4K
Q2 Net-_Q1-Pad1_ Net-_R1-Pad1_ Net-_Q2-Pad3_ eSim_NPN
Q3 Net-_R2-Pad1_ Net-_Q1-Pad1_ Net-_R4-Pad2_ eSim_NPN
R2 Net-_R2-Pad1_ Net-_R1-Pad2_ 2K
Q18 Net-_Q18-Pad1_ Net-_R15-Pad2_ Net-_R4-Pad1_ eSim_NPN
R15 Net-_R4-Pad1_ Net-_R15-Pad2_ 1K
Q19 Net-_Q19-Pad1_ Net-_R17-Pad2_ Net-_R4-Pad1_ eSim_NPN
Q7 Net-_Q7-Pad1_ Net-_R9-Pad2_ Net-_R4-Pad1_ eSim_NPN
Q6 Net-_Q6-Pad1_ Net-_R5-Pad2_ Net-_R4-Pad1_ eSim_NPN
Q14 Net-_Q13-Pad1_ Net-_R11-Pad1_ Net-_Q14-Pad3_ eSim_NPN
R11 Net-_R11-Pad1_ Net-_R1-Pad2_ 4K
Q13 Net-_Q13-Pad1_ Net-_R11-Pad1_ Net-_Q13-Pad3_ eSim_NPN
D2 Net-_R4-Pad1_ Net-_Q2-Pad3_ eSim_Diode
R4 Net-_R4-Pad1_ Net-_R4-Pad2_ 800
D1 Net-_R4-Pad1_ Net-_Q1-Pad3_ eSim_Diode
Q21 Net-_Q21-Pad1_ Net-_R19-Pad2_ Net-_R4-Pad1_ eSim_NPN
R17 Net-_R4-Pad1_ Net-_R17-Pad2_ 1K
R19 Net-_R4-Pad1_ Net-_R19-Pad2_ 800
Q22 Net-_R18-Pad1_ Net-_Q22-Pad2_ Net-_R19-Pad2_ eSim_NPN
Q20 Net-_R16-Pad1_ Net-_Q21-Pad1_ Net-_R17-Pad2_ eSim_NPN
R16 Net-_R16-Pad1_ Net-_R1-Pad2_ 1.6K
D10 Net-_R18-Pad1_ Net-_Q21-Pad1_ eSim_Diode
D11 Net-_R4-Pad1_ Net-_Q23-Pad3_ eSim_Diode
R18 Net-_R18-Pad1_ Net-_R1-Pad2_ 2K
Q24 Net-_Q22-Pad2_ Net-_R20-Pad1_ Net-_Q24-Pad3_ eSim_NPN
D12 Net-_R4-Pad1_ Net-_Q24-Pad3_ eSim_Diode
Q23 Net-_Q22-Pad2_ Net-_R20-Pad1_ Net-_Q23-Pad3_ eSim_NPN
R20 Net-_R20-Pad1_ Net-_R1-Pad2_ 4K
R8 Net-_R8-Pad1_ Net-_R1-Pad2_ 4K
D5 Net-_R4-Pad1_ Net-_Q11-Pad3_ eSim_Diode
Q11 Net-_Q10-Pad2_ Net-_R8-Pad1_ Net-_Q11-Pad3_ eSim_NPN
Q12 Net-_Q10-Pad2_ Net-_R8-Pad1_ Net-_Q12-Pad3_ eSim_NPN
D6 Net-_R4-Pad1_ Net-_Q12-Pad3_ eSim_Diode
R10 Net-_R4-Pad1_ Net-_R10-Pad2_ 800
Q10 Net-_R7-Pad1_ Net-_Q10-Pad2_ Net-_R10-Pad2_ eSim_NPN
R7 Net-_R7-Pad1_ Net-_R1-Pad2_ 2K
Q8 Net-_R6-Pad1_ Net-_Q8-Pad2_ Net-_R9-Pad2_ eSim_NPN
R6 Net-_R6-Pad1_ Net-_R1-Pad2_ 1.6K
D4 Net-_R7-Pad1_ Net-_Q8-Pad2_ eSim_Diode
R9 Net-_R4-Pad1_ Net-_R9-Pad2_ 1K
Q9 Net-_Q8-Pad2_ Net-_R10-Pad2_ Net-_R4-Pad1_ eSim_NPN
.end
