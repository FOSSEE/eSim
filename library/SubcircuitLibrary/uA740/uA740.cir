.title KiCad schematic
Q20 Net-_Q20-Pad1_ Net-_Q20-Pad2_ Net-_Q13-Pad1_ eSim_NPN
R20 Net-_Q13-Pad1_ Net-_Q21-Pad3_ 20k
Q21 Net-_Q10-Pad1_ Net-_Q20-Pad1_ Net-_Q21-Pad3_ eSim_NPN
Q28 Net-_Q13-Pad1_ Net-_C1-Pad2_ Net-_Q28-Pad3_ eSim_PNP
Q27 Net-_Q13-Pad1_ Net-_C1-Pad2_ Net-_Q20-Pad1_ eSim_PNP
R28 Net-_Q32-Pad2_ Net-_Q31-Pad3_ 30
R25 Net-_Q32-Pad3_ Net-_Q31-Pad3_ 500
Q34 Net-_Q13-Pad1_ Net-_Q28-Pad3_ Net-_Q32-Pad2_ eSim_PNP
R26 Net-_Q13-Pad1_ Net-_Q20-Pad2_ 20k
Q26 Net-_Q20-Pad2_ Net-_Q20-Pad2_ Net-_Q13-Pad1_ eSim_NPN
R23 Net-_Q25-Pad3_ Net-_Q28-Pad3_ 50k
Q32 Net-_Q20-Pad2_ Net-_Q32-Pad2_ Net-_Q32-Pad3_ eSim_PNP
U1 Net-_Q1-Pad3_ Net-_J1-Pad2_ Net-_J2-Pad2_ Net-_Q13-Pad1_ Net-_Q12-Pad3_ Net-_Q31-Pad3_ Net-_Q10-Pad1_ unconnected-_U1-Pad8_ PORT
R27 Net-_Q31-Pad3_ Net-_Q24-Pad2_ 27
Q33 Net-_Q10-Pad1_ Net-_Q25-Pad1_ Net-_Q24-Pad2_ eSim_NPN
Q22 Net-_C1-Pad2_ Net-_Q21-Pad3_ Net-_Q20-Pad2_ eSim_NPN
R22 Net-_Q13-Pad1_ Net-_Q20-Pad2_ 100
C1 Net-_C1-Pad1_ Net-_C1-Pad2_ 50p
R21 Net-_Q23-Pad3_ Net-_Q10-Pad1_ 300
R19 Net-_C1-Pad1_ Net-_Q20-Pad1_ 500
Q23 Net-_C1-Pad2_ Net-_Q18-Pad2_ Net-_Q23-Pad3_ eSim_PNP
Q29 Net-_Q25-Pad1_ Net-_Q18-Pad2_ Net-_Q29-Pad3_ eSim_PNP
Q30 Net-_Q25-Pad1_ Net-_Q25-Pad3_ Net-_Q28-Pad3_ eSim_NPN
Q31 Net-_Q25-Pad1_ Net-_Q24-Pad2_ Net-_Q31-Pad3_ eSim_NPN
R24 Net-_Q29-Pad3_ Net-_Q10-Pad1_ 1k
Q25 Net-_Q25-Pad1_ Net-_Q25-Pad1_ Net-_Q25-Pad3_ eSim_NPN
Q24 Net-_Q13-Pad1_ Net-_Q24-Pad2_ Net-_C1-Pad2_ eSim_PNP
Q1 Net-_J1-Pad1_ Net-_Q1-Pad2_ Net-_Q1-Pad3_ eSim_PNP
R1 Net-_Q1-Pad3_ Net-_Q10-Pad1_ 1k
Q3 Net-_Q10-Pad1_ Net-_J1-Pad1_ Net-_Q3-Pad3_ eSim_NPN
Q4 Net-_Q4-Pad1_ Net-_Q3-Pad3_ Net-_Q4-Pad3_ eSim_PNP
R4 Net-_Q4-Pad3_ Net-_Q7-Pad1_ 2k
R6 Net-_Q7-Pad3_ Net-_Q10-Pad1_ 500
Q7 Net-_Q7-Pad1_ Net-_Q1-Pad2_ Net-_Q7-Pad3_ eSim_PNP
Q8 Net-_Q20-Pad1_ Net-_Q10-Pad3_ Net-_Q8-Pad3_ eSim_PNP
R10 Net-_J2-Pad3_ Net-_Q10-Pad3_ 7.5k
Q10 Net-_Q10-Pad1_ Net-_J2-Pad1_ Net-_Q10-Pad3_ eSim_NPN
R8 Net-_Q8-Pad3_ Net-_Q7-Pad1_ 2k
J2 Net-_J2-Pad1_ Net-_J2-Pad2_ Net-_J2-Pad3_ jfet_p
Q12 Net-_J2-Pad1_ Net-_Q1-Pad2_ Net-_Q12-Pad3_ eSim_PNP
R11 Net-_Q12-Pad3_ Net-_Q10-Pad1_ 1k
Q2 Net-_J1-Pad3_ Net-_Q11-Pad2_ Net-_Q2-Pad3_ eSim_NPN
R3 Net-_J1-Pad3_ Net-_Q3-Pad3_ 7.5k
R5 Net-_Q13-Pad1_ Net-_Q5-Pad3_ 500
R2 Net-_Q13-Pad1_ Net-_Q2-Pad3_ 1.65k
Q5 Net-_Q4-Pad1_ Net-_Q5-Pad2_ Net-_Q5-Pad3_ eSim_NPN
J1 Net-_J1-Pad1_ Net-_J1-Pad2_ Net-_J1-Pad3_ jfet_p
R9 Net-_Q13-Pad1_ Net-_Q9-Pad3_ 500
R7 Net-_Q13-Pad1_ Net-_Q5-Pad2_ 20k
Q9 Net-_Q20-Pad1_ Net-_Q5-Pad2_ Net-_Q9-Pad3_ eSim_NPN
Q16 Net-_Q11-Pad2_ Net-_Q16-Pad2_ Net-_Q13-Pad1_ eSim_NPN
R16 Net-_Q17-Pad3_ Net-_Q16-Pad2_ 1.5k
R18 Net-_Q13-Pad1_ Net-_Q17-Pad3_ 3.3k
R14 Net-_Q13-Pad1_ Net-_Q15-Pad3_ 3.3k
Q15 Net-_Q13-Pad2_ Net-_Q11-Pad2_ Net-_Q15-Pad3_ eSim_NPN
Q11 Net-_J2-Pad3_ Net-_Q11-Pad2_ Net-_Q11-Pad3_ eSim_NPN
R12 Net-_Q13-Pad1_ Net-_Q11-Pad3_ 1.65k
Q6 Net-_Q10-Pad1_ Net-_Q4-Pad1_ Net-_Q5-Pad2_ eSim_NPN
R17 Net-_Q18-Pad3_ Net-_Q10-Pad1_ 1k
Q18 Net-_Q17-Pad1_ Net-_Q18-Pad2_ Net-_Q18-Pad3_ eSim_PNP
R13 Net-_Q14-Pad3_ Net-_Q10-Pad1_ 1k
Q19 Net-_Q13-Pad1_ Net-_Q17-Pad1_ Net-_Q18-Pad2_ eSim_PNP
Q14 Net-_Q13-Pad2_ Net-_Q1-Pad2_ Net-_Q14-Pad3_ eSim_PNP
Q17 Net-_Q17-Pad1_ Net-_Q11-Pad2_ Net-_Q17-Pad3_ eSim_NPN
Q13 Net-_Q13-Pad1_ Net-_Q13-Pad2_ Net-_Q1-Pad2_ eSim_PNP
R15 Net-_Q11-Pad2_ Net-_Q10-Pad1_ 39k
.end
