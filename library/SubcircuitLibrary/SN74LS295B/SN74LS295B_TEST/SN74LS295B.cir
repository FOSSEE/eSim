.title KiCad schematic
U8 Net-_U5-Pad2_ Net-_U11-Pad2_ d_buffer
U5 Net-_U16-Pad1_ Net-_U5-Pad2_ d_inverter
U1 Net-_U1-Pad1_ Net-_U1-Pad2_ Net-_U1-Pad3_ Net-_U1-Pad4_ Net-_U1-Pad5_ Net-_U1-Pad6_ unconnected-_U1-Pad7_ Net-_U1-Pad8_ Net-_U1-Pad9_ Net-_U1-Pad10_ Net-_U1-Pad11_ Net-_U1-Pad12_ Net-_U1-Pad13_ unconnected-_U1-Pad14_ PORT
U4 Net-_U2-Pad2_ Net-_U4-Pad2_ d_buffer
U2 Net-_U1-Pad9_ Net-_U2-Pad2_ d_inverter
U6 Net-_U1-Pad8_ Net-_U15-Pad2_ d_buffer
U7 Net-_U4-Pad2_ Net-_U13-Pad1_ d_inverter
U3 Net-_U1-Pad6_ Net-_U16-Pad1_ d_inverter
U25 Net-_U1-Pad4_ Net-_U11-Pad2_ Net-_U24-Pad1_ d_and
U28 Net-_U26-Pad2_ Net-_U24-Pad3_ Net-_U27-Pad2_ unconnected-_U28-Pad4_ unconnected-_U28-Pad5_ Net-_U28-Pad6_ unconnected-_U28-Pad7_ d_srff
U22 Net-_U21-Pad6_ Net-_U15-Pad2_ Net-_U1-Pad12_ d_tristate
U23 Net-_U16-Pad1_ Net-_U21-Pad6_ Net-_U23-Pad3_ d_and
U24 Net-_U24-Pad1_ Net-_U23-Pad3_ Net-_U24-Pad3_ d_nor
U26 Net-_U24-Pad3_ Net-_U26-Pad2_ d_inverter
U27 Net-_U13-Pad1_ Net-_U27-Pad2_ d_inverter
U31 Net-_U31-Pad1_ Net-_U30-Pad3_ Net-_U31-Pad3_ d_nor
U30 Net-_U16-Pad1_ Net-_U28-Pad6_ Net-_U30-Pad3_ d_and
U32 Net-_U1-Pad5_ Net-_U11-Pad2_ Net-_U31-Pad1_ d_and
U35 Net-_U33-Pad2_ Net-_U31-Pad3_ Net-_U34-Pad2_ unconnected-_U35-Pad4_ unconnected-_U35-Pad5_ Net-_U35-Pad6_ unconnected-_U35-Pad7_ d_srff
U33 Net-_U31-Pad3_ Net-_U33-Pad2_ d_inverter
U34 Net-_U13-Pad1_ Net-_U34-Pad2_ d_inverter
U29 Net-_U28-Pad6_ Net-_U15-Pad2_ Net-_U1-Pad11_ d_tristate
U36 Net-_U35-Pad6_ Net-_U15-Pad2_ Net-_U1-Pad10_ d_tristate
U18 Net-_U1-Pad3_ Net-_U11-Pad2_ Net-_U17-Pad1_ d_and
U20 Net-_U13-Pad1_ Net-_U20-Pad2_ d_inverter
U21 Net-_U19-Pad2_ Net-_U17-Pad3_ Net-_U20-Pad2_ unconnected-_U21-Pad4_ unconnected-_U21-Pad5_ Net-_U21-Pad6_ unconnected-_U21-Pad7_ d_srff
U19 Net-_U17-Pad3_ Net-_U19-Pad2_ d_inverter
U17 Net-_U17-Pad1_ Net-_U16-Pad3_ Net-_U17-Pad3_ d_nor
U16 Net-_U16-Pad1_ Net-_U14-Pad6_ Net-_U16-Pad3_ d_and
U14 Net-_U12-Pad2_ Net-_U10-Pad3_ Net-_U13-Pad2_ unconnected-_U14-Pad4_ unconnected-_U14-Pad5_ Net-_U14-Pad6_ unconnected-_U14-Pad7_ d_srff
U12 Net-_U10-Pad3_ Net-_U12-Pad2_ d_inverter
U13 Net-_U13-Pad1_ Net-_U13-Pad2_ d_inverter
U9 Net-_U16-Pad1_ Net-_U1-Pad1_ Net-_U10-Pad2_ d_and
U11 Net-_U1-Pad2_ Net-_U11-Pad2_ Net-_U10-Pad1_ d_and
U10 Net-_U10-Pad1_ Net-_U10-Pad2_ Net-_U10-Pad3_ d_nor
U15 Net-_U14-Pad6_ Net-_U15-Pad2_ Net-_U1-Pad13_ d_tristate
.end
