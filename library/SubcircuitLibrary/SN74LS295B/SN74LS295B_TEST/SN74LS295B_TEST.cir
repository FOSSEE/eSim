.title KiCad schematic
U3 Net-_U3-Pad1_ Net-_U3-Pad2_ Net-_U3-Pad3_ Net-_U3-Pad4_ QA QB QC QD dac_bridge_4
X1 Net-_U1-Pad5_ Net-_U2-Pad5_ Net-_U2-Pad6_ Net-_U2-Pad7_ Net-_U2-Pad8_ Net-_U1-Pad8_ unconnected-_X1-Pad7_ Net-_X1-Pad8_ Net-_U1-Pad7_ Net-_U3-Pad4_ Net-_U3-Pad3_ Net-_U3-Pad2_ Net-_U3-Pad1_ unconnected-_X1-Pad14_ SN74LS295B
U1 SER OC CLK LD/SH_BAR Net-_U1-Pad5_ Net-_X1-Pad8_ Net-_U1-Pad7_ Net-_U1-Pad8_ adc_bridge_4
U2 Net-_U2-Pad1_ GND Net-_U2-Pad1_ GND Net-_U2-Pad5_ Net-_U2-Pad6_ Net-_U2-Pad7_ Net-_U2-Pad8_ adc_bridge_4
v4 Net-_U2-Pad1_ GND 5
v6 OC GND 5
v1 SER GND pwl
v2 CLK GND pulse
v3 LD/SH_BAR GND pwl
.end
