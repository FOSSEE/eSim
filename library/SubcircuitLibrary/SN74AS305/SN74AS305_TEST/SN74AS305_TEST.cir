.title KiCad schematic
U4 Net-_U4-Pad1_ Net-_U4-Pad2_ Net-_U4-Pad3_ Net-_U4-Pad4_ Net-_U4-Pad5_ Net-_U4-Pad6_ Net-_U4-Pad7_ Net-_U4-Pad8_ Q1 Q2 Q3 Q4 Q5_BAR Q6_BAR Q7_BAR Q8_BAR dac_bridge_8
U1 Net-_U1-Pad1_ Net-_U1-Pad2_ adc_bridge_1
U2 Net-_U2-Pad1_ Net-_U2-Pad2_ adc_bridge_1
U3 Net-_U3-Pad1_ Net-_U3-Pad2_ adc_bridge_1
X1 Net-_U4-Pad3_ Net-_U4-Pad4_ Net-_U4-Pad5_ Net-_U4-Pad6_ Net-_U4-Pad7_ Net-_U4-Pad8_ Net-_U1-Pad2_ Net-_U2-Pad2_ Net-_U3-Pad2_ Net-_U4-Pad1_ Net-_U4-Pad2_ SN74AS305
v1 Net-_U1-Pad1_ GND pwl
v2 Net-_U2-Pad1_ GND pulse
v3 Net-_U3-Pad1_ GND pwl
.end
