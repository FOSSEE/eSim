.title KiCad schematic
Q1 Net-_Q1-Pad1_ Net-_Q1-Pad2_ Net-_Q1-Pad3_ eSim_NPN
Q3 Net-_Q3-Pad1_ Net-_Q3-Pad2_ Net-_Q1-Pad3_ eSim_NPN
U1 Net-_Q2-Pad2_ Net-_Q2-Pad3_ Net-_D1-Pad2_ Net-_D1-Pad1_ Net-_R4-Pad2_ Net-_Q3-Pad1_ GND Net-_Q3-Pad2_ Net-_Q1-Pad1_ Net-_Q1-Pad2_ PORT
Q2 Net-_Q1-Pad3_ Net-_Q2-Pad2_ Net-_Q2-Pad3_ eSim_NPN
D1 Net-_D1-Pad1_ Net-_D1-Pad2_ eSim_Diode
R3 Net-_Q3-Pad2_ Net-_Q1-Pad2_ 3k
R1 Net-_Q3-Pad2_ Net-_Q1-Pad1_ 3k
R4 Net-_Q1-Pad2_ Net-_R4-Pad2_ 18k
R2 Net-_D1-Pad1_ Net-_Q3-Pad2_ 3k
.end
