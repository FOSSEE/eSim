* C:\FOSSEE\eSim\library\SubcircuitLibrary\MC33171\MC33171.cir

* EESchema Netlist Version 1.1 (Spice format) creation date: 05/16/26 11:42:47

* To exclude a component from the Spice Netlist add [Spice_Netlist_Enabled] user FIELD set to: N
* To reorder the component spice node sequence add [Spice_Node_Sequence] user FIELD and define sequence: 2,1,0

* Sheet Name: /
Q7  Net-_C2-Pad2_ Net-_D1-Pad1_ Net-_Q7-Pad3_ eSim_NPN
Q1  Net-_Q1-Pad1_ Net-_Q1-Pad2_ Net-_Q1-Pad3_ eSim_PNP
Q4  Net-_Q3-Pad3_ Net-_Q1-Pad2_ Net-_Q1-Pad3_ eSim_PNP
Q6  Net-_Q6-Pad1_ Net-_Q1-Pad2_ Net-_Q1-Pad3_ eSim_PNP
Q9  Net-_Q11-Pad3_ Net-_Q1-Pad2_ Net-_Q1-Pad3_ eSim_PNP
Q12  Net-_Q10-Pad3_ Net-_Q1-Pad2_ Net-_Q1-Pad3_ eSim_PNP
Q14  Net-_D2-Pad1_ Net-_Q1-Pad2_ Net-_Q1-Pad3_ eSim_PNP
Q2  Net-_Q10-Pad1_ Net-_Q1-Pad1_ Net-_Q1-Pad2_ eSim_PNP
Q3  Net-_Q10-Pad1_ Net-_Q3-Pad2_ Net-_Q3-Pad3_ eSim_PNP
Q8  Net-_C2-Pad2_ Net-_Q11-Pad3_ Net-_C1-Pad1_ eSim_PNP
Q5  Net-_D1-Pad1_ Net-_Q3-Pad3_ Net-_C1-Pad2_ eSim_PNP
R1  Net-_Q6-Pad1_ Net-_C1-Pad2_ 30M
C1  Net-_C1-Pad1_ Net-_C1-Pad2_ 86pf
R3  Net-_Q6-Pad1_ Net-_C1-Pad1_ 50K
Q11  Net-_Q10-Pad1_ Net-_Q11-Pad2_ Net-_Q11-Pad3_ eSim_PNP
R4  Net-_Q7-Pad3_ Net-_Q10-Pad1_ 200
D1  Net-_D1-Pad1_ Net-_D1-Pad2_ eSim_Diode
R2  Net-_D1-Pad2_ Net-_Q10-Pad1_ 200
Q13  Net-_D2-Pad1_ Net-_Q10-Pad3_ Net-_Q13-Pad3_ eSim_NPN
Q10  Net-_Q10-Pad1_ Net-_C2-Pad2_ Net-_Q10-Pad3_ eSim_PNP
Q16  Net-_D2-Pad2_ Net-_Q13-Pad3_ Net-_Q10-Pad1_ eSim_NPN
Q18  Net-_C2-Pad1_ Net-_Q13-Pad3_ Net-_Q10-Pad1_ eSim_NPN
R5  Net-_Q13-Pad3_ Net-_Q10-Pad1_ 22
D2  Net-_D2-Pad1_ Net-_D2-Pad2_ eSim_Diode
Q15  Net-_Q1-Pad3_ Net-_D2-Pad1_ Net-_C2-Pad1_ eSim_NPN
Q17  Net-_D2-Pad1_ Net-_C2-Pad1_ Net-_Q17-Pad3_ eSim_NPN
R6  Net-_C2-Pad1_ Net-_D2-Pad2_ 2.5k
R7  Net-_Q17-Pad3_ Net-_C2-Pad1_ 2.5k
D3  Net-_C2-Pad1_ Net-_D2-Pad2_ eSim_Diode
R8  Net-_Q19-Pad3_ Net-_Q17-Pad3_ 37
Q19  Net-_Q19-Pad1_ Net-_C2-Pad1_ Net-_Q19-Pad3_ eSim_PNP
C2  Net-_C2-Pad1_ Net-_C2-Pad2_ 15pf
U1  Net-_D1-Pad2_ Net-_Q3-Pad2_ Net-_Q11-Pad2_ Net-_Q10-Pad1_ Net-_Q7-Pad3_ Net-_Q17-Pad3_ Net-_Q1-Pad3_ ? PORT

.end
