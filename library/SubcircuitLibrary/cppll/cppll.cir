.title KiCad schematic
U1 Net-_R1-Pad2_ Net-_R2-Pad1_ Net-_R3-Pad2_ Net-_R5-Pad1_ Net-_G_CP1-Pad1_ PORT
R1 GND Net-_R1-Pad2_ 1G
B_PD1 Net-_G_CP1-Pad3_ GND V = sgn(v(REF_IN)) * sgn(v(VCO_FB))
R2 Net-_R2-Pad1_ GND 1G
R5 Net-_R5-Pad1_ GND 1G
G_CP1 Net-_G_CP1-Pad1_ GND Net-_G_CP1-Pad3_ GND VCCS
B_VCO1 Net-_G_CP1-Pad1_ GND V = sin(2*3.14159*1Meg*time + 2*3.14159*1Meg*sdt(v(VCO_IN)))
R4 Net-_G_CP1-Pad1_ GND 1G
R3 GND Net-_R3-Pad2_ 1G
.end
