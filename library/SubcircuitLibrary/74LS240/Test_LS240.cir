.title KiCad schematic
v10 A5 GND pulse
v5 A4 GND pulse
U9 A5 Net-_U9-Pad2_ adc_bridge_1
U4 A6 Net-_U4-Pad2_ adc_bridge_1
U3 A4 Net-_U3-Pad2_ adc_bridge_1
v8 A8 GND pulse
v6 A6 GND pulse
v7 A7 GND pulse
U5 A7 Net-_U5-Pad2_ adc_bridge_1
U6 A8 Net-_U6-Pad2_ adc_bridge_1
X1 Net-_U10-Pad2_ Net-_U8-Pad2_ Net-_U1-Pad2_ Net-_U2-Pad2_ Net-_U3-Pad2_ Net-_U13-Pad1_ Net-_U14-Pad1_ Net-_U15-Pad1_ Net-_U11-Pad1_ Net-_U9-Pad2_ Net-_U4-Pad2_ Net-_U5-Pad2_ Net-_U6-Pad2_ Net-_U12-Pad1_ Net-_U16-Pad1_ Net-_U17-Pad1_ Net-_U18-Pad1_ Net-_U7-Pad2_ LS240
v1 OE2 GND pulse
v2 OE1 GND pulse
v4 A3 GND pulse
v3 A2 GND pulse
v9 A1 GND pulse
U8 A1 Net-_U8-Pad2_ adc_bridge_1
U10 OE1 Net-_U10-Pad2_ adc_bridge_1
U7 OE2 Net-_U7-Pad2_ adc_bridge_1
U2 A3 Net-_U2-Pad2_ adc_bridge_1
U1 A2 Net-_U1-Pad2_ adc_bridge_1
U18 Net-_U18-Pad1_ Y8 dac_bridge_1
U17 Net-_U17-Pad1_ Y7 dac_bridge_1
U16 Net-_U16-Pad1_ Y6 dac_bridge_1
U12 Net-_U12-Pad1_ Y5 dac_bridge_1
U15 Net-_U15-Pad1_ Y3 dac_bridge_1
U11 Net-_U11-Pad1_ Y4 dac_bridge_1
U13 Net-_U13-Pad1_ Y1 dac_bridge_1
U14 Net-_U14-Pad1_ Y2 dac_bridge_1
.end
