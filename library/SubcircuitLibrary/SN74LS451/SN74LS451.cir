.title KiCad schematic
X18 Net-_X18-Pad1_ Net-_X18-Pad2_ Net-_X18-Pad3_ Net-_X18-Pad4_ Net-_U26-Pad2_ 4_OR
X5 Net-_U19-Pad2_ Net-_U21-Pad2_ Net-_U6-Pad2_ Net-_U22-Pad2_ Net-_U25-Pad2_ Net-_X18-Pad1_ 5_and
X3 Net-_U19-Pad2_ Net-_U20-Pad2_ Net-_U4-Pad2_ Net-_U23-Pad2_ Net-_U25-Pad2_ Net-_X17-Pad3_ 5_and
X4 Net-_U18-Pad2_ Net-_U20-Pad2_ Net-_U5-Pad2_ Net-_U23-Pad2_ Net-_U25-Pad2_ Net-_X17-Pad4_ 5_and
X7 Net-_U19-Pad2_ Net-_U20-Pad2_ Net-_U8-Pad2_ Net-_U22-Pad2_ Net-_U25-Pad2_ Net-_X18-Pad3_ 5_and
X8 Net-_U18-Pad2_ Net-_U20-Pad2_ Net-_U9-Pad2_ Net-_U22-Pad2_ Net-_U25-Pad2_ Net-_X18-Pad4_ 5_and
X6 Net-_U18-Pad2_ Net-_U21-Pad2_ Net-_U7-Pad2_ Net-_U22-Pad2_ Net-_U25-Pad2_ Net-_X18-Pad2_ 5_and
U26 Net-_U26-Pad1_ Net-_U26-Pad2_ Net-_U1-Pad18_ d_nor
U1 Net-_U1-Pad1_ Net-_U1-Pad2_ Net-_U1-Pad3_ Net-_U1-Pad4_ Net-_U1-Pad5_ Net-_U1-Pad6_ Net-_U1-Pad7_ Net-_U1-Pad8_ Net-_U1-Pad9_ Net-_U1-Pad10_ Net-_U1-Pad11_ Net-_U1-Pad12_ Net-_U1-Pad13_ Net-_U1-Pad14_ Net-_U1-Pad15_ Net-_U1-Pad16_ Net-_U1-Pad17_ Net-_U1-Pad18_ Net-_U1-Pad19_ Net-_U1-Pad20_ Net-_U1-Pad21_ Net-_U1-Pad22_ PORT
X17 Net-_X1-Pad6_ Net-_X17-Pad2_ Net-_X17-Pad3_ Net-_X17-Pad4_ Net-_U26-Pad1_ 4_OR
U5 Net-_U1-Pad4_ Net-_U5-Pad2_ d_inverter
U4 Net-_U1-Pad3_ Net-_U4-Pad2_ d_inverter
U3 Net-_U1-Pad2_ Net-_U3-Pad2_ d_inverter
U2 Net-_U1-Pad1_ Net-_U2-Pad2_ d_inverter
U6 Net-_U1-Pad5_ Net-_U6-Pad2_ d_inverter
U8 Net-_U1-Pad7_ Net-_U8-Pad2_ d_inverter
U7 Net-_U1-Pad6_ Net-_U7-Pad2_ d_inverter
U9 Net-_U1-Pad8_ Net-_U9-Pad2_ d_inverter
U19 Net-_U18-Pad2_ Net-_U19-Pad2_ d_inverter
U21 Net-_U20-Pad2_ Net-_U21-Pad2_ d_inverter
U20 Net-_U1-Pad21_ Net-_U20-Pad2_ d_buffer
U18 Net-_U1-Pad22_ Net-_U18-Pad2_ d_buffer
U22 Net-_U1-Pad20_ Net-_U22-Pad2_ d_buffer
U24 Net-_U1-Pad19_ Net-_U24-Pad2_ d_buffer
X1 Net-_U19-Pad2_ Net-_U21-Pad2_ Net-_U2-Pad2_ Net-_U23-Pad2_ Net-_U25-Pad2_ Net-_X1-Pad6_ 5_and
X2 Net-_U18-Pad2_ Net-_U21-Pad2_ Net-_U3-Pad2_ Net-_U23-Pad2_ Net-_U25-Pad2_ Net-_X17-Pad2_ 5_and
U25 Net-_U24-Pad2_ Net-_U25-Pad2_ d_inverter
U23 Net-_U22-Pad2_ Net-_U23-Pad2_ d_inverter
U14 Net-_U1-Pad13_ Net-_U14-Pad2_ d_inverter
U15 Net-_U1-Pad14_ Net-_U15-Pad2_ d_inverter
U16 Net-_U1-Pad15_ Net-_U16-Pad2_ d_inverter
U17 Net-_U1-Pad16_ Net-_U17-Pad2_ d_inverter
X16 Net-_U18-Pad2_ Net-_U20-Pad2_ Net-_U17-Pad2_ Net-_U22-Pad2_ Net-_U25-Pad2_ Net-_X16-Pad6_ 5_and
X15 Net-_U19-Pad2_ Net-_U20-Pad2_ Net-_U16-Pad2_ Net-_U22-Pad2_ Net-_U25-Pad2_ Net-_X15-Pad6_ 5_and
U27 Net-_U27-Pad1_ Net-_U27-Pad2_ Net-_U1-Pad17_ d_nor
X13 Net-_U19-Pad2_ Net-_U21-Pad2_ Net-_U14-Pad2_ Net-_U22-Pad2_ Net-_U25-Pad2_ Net-_X13-Pad6_ 5_and
X14 Net-_U18-Pad2_ Net-_U21-Pad2_ Net-_U15-Pad2_ Net-_U22-Pad2_ Net-_U25-Pad2_ Net-_X14-Pad6_ 5_and
X20 Net-_X13-Pad6_ Net-_X14-Pad6_ Net-_X15-Pad6_ Net-_X16-Pad6_ Net-_U27-Pad2_ 4_OR
X19 Net-_X19-Pad1_ Net-_X10-Pad6_ Net-_X11-Pad6_ Net-_X12-Pad6_ Net-_U27-Pad1_ 4_OR
X12 Net-_U18-Pad2_ Net-_U20-Pad2_ Net-_U13-Pad2_ Net-_U23-Pad2_ Net-_U25-Pad2_ Net-_X12-Pad6_ 5_and
U12 Net-_U1-Pad11_ Net-_U12-Pad2_ d_inverter
U13 Net-_U1-Pad12_ Net-_U13-Pad2_ d_inverter
X10 Net-_U18-Pad2_ Net-_U21-Pad2_ Net-_U11-Pad2_ Net-_U23-Pad2_ Net-_U25-Pad2_ Net-_X10-Pad6_ 5_and
X9 Net-_U19-Pad2_ Net-_U21-Pad2_ Net-_U10-Pad2_ Net-_U23-Pad2_ Net-_U25-Pad2_ Net-_X19-Pad1_ 5_and
X11 Net-_U19-Pad2_ Net-_U20-Pad2_ Net-_U12-Pad2_ Net-_U23-Pad2_ Net-_U25-Pad2_ Net-_X11-Pad6_ 5_and
U11 Net-_U1-Pad10_ Net-_U11-Pad2_ d_inverter
U10 Net-_U1-Pad9_ Net-_U10-Pad2_ d_inverter
.end
