.title KiCad schematic
U3 Net-_U1-Pad5_ Net-_U1-Pad6_ Net-_U1-Pad7_ Net-_U1-Pad8_ Net-_U2-Pad5_ Net-_U2-Pad6_ Net-_U2-Pad7_ Net-_U2-Pad8_ Net-_U3-Pad9_ Net-_U3-Pad10_ Net-_U3-Pad11_ Net-_U3-Pad12_ 74LS125
U7 Net-_U4-Pad7_ plot_v1
U8 Net-_U4-Pad8_ plot_v1
U5 Net-_U4-Pad5_ plot_v1
U6 Net-_U4-Pad6_ plot_v1
U4 Net-_U3-Pad9_ Net-_U3-Pad10_ Net-_U3-Pad11_ Net-_U3-Pad12_ Net-_U4-Pad5_ Net-_U4-Pad6_ Net-_U4-Pad7_ Net-_U4-Pad8_ dac_bridge_4
v4 Net-_U1-Pad4_ GND pulse
v6 unconnected-_v6-Pad1_ GND pulse
v5 Net-_U2-Pad1_ GND pulse
v3 Net-_U1-Pad3_ GND pulse
v2 Net-_U1-Pad2_ GND pulse
v1 Net-_U1-Pad1_ GND pulse
U1 Net-_U1-Pad1_ Net-_U1-Pad2_ Net-_U1-Pad3_ Net-_U1-Pad4_ Net-_U1-Pad5_ Net-_U1-Pad6_ Net-_U1-Pad7_ Net-_U1-Pad8_ adc_bridge_4
U2 Net-_U2-Pad1_ Net-_U2-Pad1_ Net-_U2-Pad1_ Net-_U2-Pad1_ Net-_U2-Pad5_ Net-_U2-Pad6_ Net-_U2-Pad7_ Net-_U2-Pad8_ adc_bridge_4
.end
