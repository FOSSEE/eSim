.title KiCad schematic
U1 Net-_U1-Pad1_ Net-_U1-Pad2_ Net-_U1-Pad3_ Net-_U1-Pad4_ Net-_U1-Pad5_ Net-_U1-Pad6_ Net-_U1-Pad7_ Net-_U1-Pad8_ Net-_U1-Pad9_ Net-_U1-Pad10_ Net-_U1-Pad11_ Net-_U1-Pad12_ PORT
U3 Net-_U1-Pad6_ Net-_U3-Pad2_ d_inverter
U7 Net-_U1-Pad5_ Net-_U3-Pad2_ Net-_U1-Pad11_ d_and
U5 Net-_U1-Pad8_ Net-_U5-Pad2_ d_inverter
U9 Net-_U1-Pad7_ Net-_U5-Pad2_ Net-_U1-Pad12_ d_and
U4 Net-_U1-Pad4_ Net-_U4-Pad2_ d_inverter
U2 Net-_U1-Pad2_ Net-_U2-Pad2_ d_inverter
U6 Net-_U1-Pad1_ Net-_U2-Pad2_ Net-_U1-Pad9_ d_and
U8 Net-_U1-Pad3_ Net-_U4-Pad2_ Net-_U1-Pad10_ d_and
.end
