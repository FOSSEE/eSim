.title KiCad schematic
R4 Net-_Q3-Pad1_ Net-_Q11-Pad1_ 2.4K
U1 Net-_Q3-Pad2_ unconnected-_U1-Pad2_ Net-_Q4-Pad1_ Net-_Q3-Pad3_ Net-_R10-Pad1_ unconnected-_U1-Pad6_ Net-_Q11-Pad3_ Net-_Q10-Pad1_ unconnected-_U1-Pad9_ Net-_Q11-Pad1_ Net-_Q1-Pad3_ Net-_Q2-Pad1_ unconnected-_U1-Pad13_ Net-_Q1-Pad2_ PORT
Q1 Net-_Q1-Pad1_ Net-_Q1-Pad2_ Net-_Q1-Pad3_ eSim_NPN
R7 Net-_Q10-Pad2_ Net-_Q11-Pad1_ 10K
Q3 Net-_Q3-Pad1_ Net-_Q3-Pad2_ Net-_Q3-Pad3_ eSim_NPN
R1 Net-_Q1-Pad1_ Net-_Q11-Pad1_ 2.4K
R6 Net-_R10-Pad1_ Net-_Q4-Pad3_ 600
Q4 Net-_Q4-Pad1_ Net-_Q10-Pad2_ Net-_Q4-Pad3_ eSim_NPN
R10 Net-_R10-Pad1_ Net-_Q7-Pad3_ 300
R8 Net-_R10-Pad1_ Net-_Q5-Pad3_ 1.4K
Q5 Net-_Q10-Pad2_ Net-_Q10-Pad2_ Net-_Q5-Pad3_ eSim_NPN
R13 Net-_Q8-Pad1_ Net-_Q11-Pad1_ 1.1K
R9 Net-_Q11-Pad2_ Net-_Q11-Pad1_ 1.1K
Q9 Net-_Q11-Pad1_ Net-_Q8-Pad1_ Net-_Q10-Pad1_ eSim_NPN
Q11 Net-_Q11-Pad1_ Net-_Q11-Pad2_ Net-_Q11-Pad3_ eSim_NPN
R3 Net-_R10-Pad1_ Net-_Q2-Pad3_ 600
Q2 Net-_Q2-Pad1_ Net-_Q10-Pad2_ Net-_Q2-Pad3_ eSim_NPN
R5 Net-_Q4-Pad1_ Net-_Q3-Pad3_ 50
R2 Net-_Q2-Pad1_ Net-_Q1-Pad3_ 50
R12 Net-_Q11-Pad3_ Net-_Q3-Pad1_ 7K
Q7 Net-_Q6-Pad3_ Net-_Q10-Pad2_ Net-_Q7-Pad3_ eSim_NPN
R14 Net-_R10-Pad1_ Net-_Q10-Pad3_ 400
Q10 Net-_Q10-Pad1_ Net-_Q10-Pad2_ Net-_Q10-Pad3_ eSim_NPN
Q12 Net-_Q11-Pad3_ Net-_Q10-Pad2_ Net-_Q12-Pad3_ eSim_NPN
R15 Net-_R10-Pad1_ Net-_Q12-Pad3_ 400
R11 Net-_Q10-Pad1_ Net-_Q1-Pad1_ 7K
Q8 Net-_Q8-Pad1_ Net-_Q1-Pad1_ Net-_Q6-Pad3_ eSim_NPN
Q6 Net-_Q11-Pad2_ Net-_Q3-Pad1_ Net-_Q6-Pad3_ eSim_NPN
.end
