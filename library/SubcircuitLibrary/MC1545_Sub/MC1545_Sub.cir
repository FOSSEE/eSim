.title KiCad schematic
R9 Net-_R11-Pad2_ Net-_Q10-Pad1_ 850
Q9 Net-_Q10-Pad1_ unconnected-_Q9-Pad2_ Net-_Q11-Pad2_ eSim_NPN
Q8 Net-_Q10-Pad1_ Net-_Q4-Pad1_ Net-_Q10-Pad2_ eSim_NPN
R11 Net-_Q3-Pad3_ Net-_R11-Pad2_ 1.0k
R14 Net-_D2-Pad1_ Net-_Q10-Pad2_ 9.0k
Q4 Net-_Q4-Pad1_ Net-_Q4-Pad2_ Net-_Q4-Pad3_ eSim_NPN
R8 Net-_Q4-Pad3_ Net-_Q6-Pad1_ 20
R7 Net-_Q4-Pad1_ Net-_R11-Pad2_ 1.0k
R3 Net-_R13-Pad1_ Net-_Q2-Pad2_ 3.8k
R6 Net-_R13-Pad1_ Net-_Q5-Pad3_ 190
Q2 Net-_Q2-Pad1_ Net-_Q2-Pad2_ Net-_Q2-Pad3_ eSim_NPN
Q5 Net-_Q2-Pad3_ Net-_D2-Pad1_ Net-_Q5-Pad3_ eSim_NPN
R1 Net-_D1-Pad1_ Net-_Q2-Pad2_ 7.8k
Q3 Net-_Q3-Pad1_ Net-_Q3-Pad2_ Net-_Q3-Pad3_ eSim_NPN
R5 Net-_Q2-Pad1_ Net-_Q3-Pad1_ 20
R4 Net-_Q1-Pad3_ Net-_Q2-Pad1_ 20
Q1 unconnected-_Q1-Pad1_ Net-_Q1-Pad2_ Net-_Q1-Pad3_ eSim_NPN
U1 Net-_D1-Pad2_ Net-_Q7-Pad2_ Net-_Q4-Pad2_ Net-_Q3-Pad2_ Net-_Q1-Pad2_ Net-_Q10-Pad3_ Net-_R13-Pad1_ Net-_Q10-Pad1_ Net-_Q11-Pad3_ PORT
R2 Net-_D1-Pad1_ Net-_Q10-Pad1_ 2.5k
D1 Net-_D1-Pad1_ Net-_D1-Pad2_ eSim_Diode
Q7 Net-_Q3-Pad3_ Net-_Q7-Pad2_ Net-_Q7-Pad3_ eSim_NPN
R10 Net-_Q6-Pad1_ Net-_Q7-Pad3_ 20
Q6 Net-_Q6-Pad1_ Net-_Q6-Pad2_ Net-_Q2-Pad3_ eSim_NPN
R12 Net-_Q6-Pad2_ Net-_Q10-Pad1_ 15k
R15 Net-_R13-Pad1_ Net-_D2-Pad2_ 500
D2 Net-_D2-Pad1_ Net-_D2-Pad2_ eSim_Diode
R13 Net-_R13-Pad1_ Net-_Q6-Pad2_ 4.0k
R17 Net-_R13-Pad1_ Net-_Q10-Pad3_ 5.0k
R18 Net-_R13-Pad1_ Net-_Q11-Pad3_ 5.0k
Q11 Net-_Q10-Pad1_ Net-_Q11-Pad2_ Net-_Q11-Pad3_ eSim_NPN
R16 Net-_D2-Pad1_ Net-_Q11-Pad2_ 9.0k
Q10 Net-_Q10-Pad1_ Net-_Q10-Pad2_ Net-_Q10-Pad3_ eSim_NPN
.end
