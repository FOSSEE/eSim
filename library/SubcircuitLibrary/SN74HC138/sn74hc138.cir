.title KiCad schematic
U14 Net-_U14-Pad1_ Net-_U11-Pad2_ Net-_U1-Pad13_ d_nand
X5 Net-_U2-Pad2_ Net-_U3-Pad2_ Net-_U10-Pad2_ Net-_U15-Pad1_ 3_and
X4 Net-_U8-Pad2_ Net-_U3-Pad2_ Net-_U10-Pad2_ Net-_U14-Pad1_ 3_and
X2 Net-_U8-Pad2_ Net-_U9-Pad2_ Net-_U10-Pad2_ Net-_U12-Pad1_ 3_and
X3 Net-_U2-Pad2_ Net-_U9-Pad2_ Net-_U10-Pad2_ Net-_U13-Pad1_ 3_and
U13 Net-_U13-Pad1_ Net-_U11-Pad2_ Net-_U1-Pad14_ d_nand
U12 Net-_U12-Pad1_ Net-_U11-Pad2_ Net-_U1-Pad15_ d_nand
U16 Net-_U16-Pad1_ Net-_U11-Pad2_ Net-_U1-Pad11_ d_nand
U1 Net-_U1-Pad1_ Net-_U1-Pad2_ Net-_U1-Pad3_ Net-_U1-Pad4_ Net-_U1-Pad5_ Net-_U1-Pad6_ Net-_U1-Pad7_ unconnected-_U1-Pad8_ Net-_U1-Pad9_ Net-_U1-Pad10_ Net-_U1-Pad11_ Net-_U1-Pad12_ Net-_U1-Pad13_ Net-_U1-Pad14_ Net-_U1-Pad15_ unconnected-_U1-Pad16_ PORT
U15 Net-_U15-Pad1_ Net-_U11-Pad2_ Net-_U1-Pad12_ d_nand
U17 Net-_U17-Pad1_ Net-_U11-Pad2_ Net-_U1-Pad10_ d_nand
U19 Net-_U19-Pad1_ Net-_U11-Pad2_ Net-_U1-Pad7_ d_nand
U18 Net-_U18-Pad1_ Net-_U11-Pad2_ Net-_U1-Pad9_ d_nand
U11 Net-_U11-Pad1_ Net-_U11-Pad2_ d_inverter
X9 Net-_U2-Pad2_ Net-_U3-Pad2_ Net-_U10-Pad1_ Net-_U19-Pad1_ 3_and
X8 Net-_U8-Pad2_ Net-_U3-Pad2_ Net-_U10-Pad1_ Net-_U18-Pad1_ 3_and
X1 Net-_U5-Pad2_ Net-_U6-Pad2_ Net-_U7-Pad2_ Net-_U11-Pad1_ 3_and
U5 Net-_U1-Pad6_ Net-_U5-Pad2_ d_inverter
U6 Net-_U1-Pad4_ Net-_U6-Pad2_ d_inverter
U7 Net-_U1-Pad5_ Net-_U7-Pad2_ d_inverter
U4 Net-_U1-Pad3_ Net-_U10-Pad1_ d_inverter
U10 Net-_U10-Pad1_ Net-_U10-Pad2_ d_inverter
U9 Net-_U3-Pad2_ Net-_U9-Pad2_ d_inverter
U8 Net-_U2-Pad2_ Net-_U8-Pad2_ d_inverter
U3 Net-_U1-Pad2_ Net-_U3-Pad2_ d_inverter
U2 Net-_U1-Pad1_ Net-_U2-Pad2_ d_inverter
X7 Net-_U2-Pad2_ Net-_U9-Pad2_ Net-_U10-Pad1_ Net-_U17-Pad1_ 3_and
X6 Net-_U8-Pad2_ Net-_U9-Pad2_ Net-_U10-Pad1_ Net-_U16-Pad1_ 3_and
.end
