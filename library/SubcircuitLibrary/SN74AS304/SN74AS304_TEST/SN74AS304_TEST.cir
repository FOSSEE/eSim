.title KiCad schematic
v2 Net-_U2-Pad1_ GND pulse
v1 Net-_U1-Pad1_ GND pwl
X1 Net-_U4-Pad3_ Net-_U4-Pad4_ Net-_U4-Pad5_ Net-_U4-Pad6_ Net-_U4-Pad7_ Net-_U4-Pad8_ Net-_U1-Pad2_ Net-_U2-Pad2_ Net-_U3-Pad2_ Net-_U4-Pad1_ Net-_U4-Pad2_ SN74AS304
U4 Net-_U4-Pad1_ Net-_U4-Pad2_ Net-_U4-Pad3_ Net-_U4-Pad4_ Net-_U4-Pad5_ Net-_U4-Pad6_ Net-_U4-Pad7_ Net-_U4-Pad8_ Q1 Q2 Q3 Q4 Q5 Q6 Q7 Q8 dac_bridge_8
U2 Net-_U2-Pad1_ Net-_U2-Pad2_ adc_bridge_1
U3 Net-_U3-Pad1_ Net-_U3-Pad2_ adc_bridge_1
U1 Net-_U1-Pad1_ Net-_U1-Pad2_ adc_bridge_1
v3 Net-_U3-Pad1_ GND pwl
.end
