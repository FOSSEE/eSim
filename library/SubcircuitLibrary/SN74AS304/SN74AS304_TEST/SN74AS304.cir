.title KiCad schematic
U1 Net-_U1-Pad1_ Net-_U1-Pad2_ Net-_U1-Pad3_ Net-_U1-Pad4_ Net-_U1-Pad5_ Net-_U1-Pad6_ Net-_U1-Pad7_ Net-_U1-Pad8_ Net-_U1-Pad9_ Net-_U1-Pad10_ Net-_U1-Pad11_ PORT
U2 Net-_U1-Pad7_ Net-_U2-Pad2_ d_inverter
U7 Net-_U10-Pad1_ Net-_U1-Pad1_ d_buffer
U4 Net-_U4-Pad1_ Net-_U1-Pad8_ Net-_U2-Pad2_ Net-_U3-Pad2_ Net-_U10-Pad1_ Net-_U4-Pad1_ d_dff
U3 Net-_U1-Pad9_ Net-_U3-Pad2_ d_inverter
U6 Net-_U10-Pad1_ Net-_U1-Pad11_ d_buffer
U5 Net-_U10-Pad1_ Net-_U1-Pad10_ d_buffer
U9 Net-_U10-Pad1_ Net-_U1-Pad3_ d_buffer
U8 Net-_U10-Pad1_ Net-_U1-Pad2_ d_buffer
U12 Net-_U10-Pad1_ Net-_U1-Pad6_ d_buffer
U11 Net-_U10-Pad1_ Net-_U1-Pad5_ d_buffer
U10 Net-_U10-Pad1_ Net-_U1-Pad4_ d_buffer
.end
