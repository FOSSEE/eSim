.title KiCad schematic
U1 Net-_U1-Pad1_ Net-_U1-Pad2_ Net-_U1-Pad3_ Net-_U1-Pad4_ Net-_U1-Pad5_ Net-_U1-Pad6_ Net-_U1-Pad7_ unconnected-_U1-Pad8_ Net-_U1-Pad9_ Net-_U1-Pad10_ Net-_U1-Pad11_ Net-_U1-Pad12_ Net-_U1-Pad13_ Net-_U1-Pad14_ Net-_U1-Pad15_ unconnected-_U1-Pad16_ PORT
U9 Net-_U1-Pad6_ Net-_U3-Pad2_ Net-_U1-Pad7_ d_tristate
U5 Net-_U1-Pad10_ Net-_U3-Pad2_ Net-_U1-Pad9_ d_tristate
U8 Net-_U1-Pad4_ Net-_U3-Pad2_ Net-_U1-Pad5_ d_tristate
U7 Net-_U1-Pad2_ Net-_U3-Pad2_ Net-_U1-Pad3_ d_tristate
U3 Net-_U1-Pad1_ Net-_U3-Pad2_ d_inverter
U6 Net-_U1-Pad12_ Net-_U2-Pad2_ Net-_U1-Pad11_ d_tristate
U2 Net-_U1-Pad15_ Net-_U2-Pad2_ d_inverter
U4 Net-_U1-Pad14_ Net-_U2-Pad2_ Net-_U1-Pad13_ d_tristate
.end
