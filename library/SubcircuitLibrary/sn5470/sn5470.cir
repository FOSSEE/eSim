.title KiCad schematic
v4 j GND pulse(0 5 0 1n 1n 2m 4m)
U5 j j j Net-_U5-Pad4_ Net-_U5-Pad5_ Net-_U5-Pad6_ adc_bridge_3
U2 j plot_v1
U1 k plot_v1
v3 k GND pulse(0 5 0 1n 1n 1m 2m)
U11 q plot_v1
R1 q GND 1k
X1 Net-_U4-Pad4_ Net-_U7-Pad2_ Net-_U6-Pad4_ unconnected-_X1-Pad4_ Net-_U6-Pad3_ unconnected-_X1-Pad6_ Net-_U5-Pad4_ Net-_U4-Pad5_ Net-_U8-Pad2_ unconnected-_X1-Pad10_ unconnected-_X1-Pad11_ Net-_U10-Pad1_ Net-_U9-Pad2_ Net-_U5-Pad5_ sn7470
U9 Net-_U5-Pad6_ Net-_U9-Pad2_ d_inverter
U10 Net-_U10-Pad1_ q dac_bridge_1
U8 Net-_U4-Pad6_ Net-_U8-Pad2_ d_inverter
U4 k k k Net-_U4-Pad4_ Net-_U4-Pad5_ Net-_U4-Pad6_ adc_bridge_3
v1 Net-_U6-Pad1_ GND 5
U6 Net-_U6-Pad1_ Net-_U6-Pad1_ Net-_U6-Pad3_ Net-_U6-Pad4_ adc_bridge_2
U7 clk Net-_U7-Pad2_ adc_bridge_1
U3 clk plot_v1
v2 clk GND pulse(0 5 0 1n 1n 0.5m 1m)
.end
