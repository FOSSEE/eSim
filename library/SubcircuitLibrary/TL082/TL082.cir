.title KiCad schematic
Q42 Net-_Q36-Pad1_ Net-_Q42-Pad2_ Net-_Q41-Pad3_ eSim_NPN
Q36 Net-_Q36-Pad1_ Net-_Q34-Pad1_ Net-_J3-Pad1_ eSim_PNP
U1 Net-_Q19-Pad3_ Net-_J1-Pad2_ Net-_J2-Pad2_ Net-_D2-Pad2_ Net-_J5-Pad2_ Net-_J4-Pad2_ Net-_Q41-Pad3_ Net-_J3-Pad1_ PORT
Q43 Net-_J3-Pad1_ Net-_Q36-Pad1_ Net-_Q42-Pad2_ eSim_NPN
Q35 Net-_Q34-Pad1_ Net-_Q34-Pad1_ Net-_J3-Pad1_ eSim_PNP
Q28 Net-_C2-Pad1_ Net-_Q23-Pad2_ Net-_Q28-Pad3_ eSim_NPN
Q23 Net-_J4-Pad3_ Net-_Q23-Pad2_ Net-_Q23-Pad3_ eSim_NPN
Q24 Net-_J3-Pad1_ Net-_J4-Pad3_ Net-_Q23-Pad2_ eSim_NPN
J4 Net-_J4-Pad1_ Net-_J4-Pad2_ Net-_J4-Pad3_ jfet_p
R14 Net-_C2-Pad1_ Net-_J5-Pad3_ 1.8k
Q26 Net-_Q23-Pad2_ Net-_D5-Pad1_ Net-_D2-Pad2_ eSim_NPN
R13 Net-_D2-Pad2_ Net-_R12-Pad1_ 100
R12 Net-_R12-Pad1_ Net-_Q23-Pad3_ 2k
J5 Net-_J4-Pad1_ Net-_J5-Pad2_ Net-_J5-Pad3_ jfet_p
Q21 Net-_J3-Pad1_ Net-_Q14-Pad1_ Net-_Q20-Pad2_ eSim_NPN
R10 Net-_Q19-Pad3_ Net-_Q20-Pad2_ 22
R11 Net-_Q19-Pad2_ Net-_Q19-Pad3_ 160
Q22 Net-_D2-Pad2_ Net-_C1-Pad2_ Net-_Q19-Pad2_ eSim_PNP
Q25 Net-_J4-Pad1_ Net-_Q25-Pad2_ Net-_Q25-Pad3_ eSim_PNP
J6 Net-_J3-Pad1_ Net-_J3-Pad1_ Net-_J6-Pad3_ jfet_p
Q27 Net-_Q25-Pad3_ Net-_Q25-Pad3_ Net-_J3-Pad1_ eSim_PNP
Q29 Net-_Q25-Pad2_ Net-_Q25-Pad3_ Net-_J3-Pad1_ eSim_PNP
Q34 Net-_Q34-Pad1_ Net-_J6-Pad3_ Net-_D4-Pad1_ eSim_NPN
D4 Net-_D4-Pad1_ Net-_D4-Pad2_ eSim_Diode
Q33 Net-_Q25-Pad2_ Net-_D4-Pad1_ Net-_D4-Pad2_ eSim_NPN
R17 Net-_D5-Pad1_ Net-_D4-Pad2_ 20k
Q38 Net-_Q36-Pad1_ Net-_Q38-Pad2_ Net-_C2-Pad2_ eSim_NPN
U3 Net-_D2-Pad2_ Net-_J6-Pad3_ zener
C2 Net-_C2-Pad1_ Net-_C2-Pad2_ 10p
Q41 Net-_D6-Pad1_ Net-_Q41-Pad2_ Net-_Q41-Pad3_ eSim_PNP
R19 Net-_C2-Pad2_ Net-_Q38-Pad2_ 6k
D6 Net-_D6-Pad1_ Net-_D2-Pad2_ eSim_Diode
R21 Net-_Q41-Pad3_ Net-_Q42-Pad2_ 22
Q44 Net-_D2-Pad2_ Net-_C2-Pad2_ Net-_Q41-Pad2_ eSim_PNP
R22 Net-_Q41-Pad2_ Net-_Q41-Pad3_ 160
Q40 Net-_Q36-Pad1_ Net-_Q36-Pad1_ Net-_Q38-Pad2_ eSim_NPN
R20 Net-_D2-Pad2_ Net-_Q39-Pad3_ 160
R15 Net-_R15-Pad1_ Net-_Q28-Pad3_ 2k
Q31 Net-_Q30-Pad3_ Net-_D5-Pad1_ Net-_D2-Pad2_ eSim_NPN
R16 Net-_D2-Pad2_ Net-_R15-Pad1_ 100
Q37 Net-_C2-Pad2_ Net-_Q30-Pad3_ Net-_Q37-Pad3_ eSim_NPN
Q30 Net-_J3-Pad1_ Net-_C2-Pad1_ Net-_Q30-Pad3_ eSim_NPN
Q32 Net-_D2-Pad2_ Net-_C2-Pad2_ Net-_C2-Pad1_ eSim_PNP
R18 Net-_D2-Pad2_ Net-_Q37-Pad3_ 30
Q39 Net-_C2-Pad1_ Net-_D6-Pad1_ Net-_Q39-Pad3_ eSim_NPN
D5 Net-_D5-Pad1_ Net-_D2-Pad2_ eSim_Diode
Q3 Net-_J1-Pad1_ Net-_Q11-Pad1_ Net-_Q3-Pad3_ eSim_PNP
Q15 Net-_C1-Pad2_ Net-_Q15-Pad2_ Net-_Q15-Pad3_ eSim_NPN
Q17 Net-_C1-Pad1_ Net-_D3-Pad1_ Net-_Q17-Pad3_ eSim_NPN
R9 Net-_D2-Pad2_ Net-_Q17-Pad3_ 160
D3 Net-_D3-Pad1_ Net-_D2-Pad2_ eSim_Diode
C1 Net-_C1-Pad1_ Net-_C1-Pad2_ 10p
Q10 Net-_D2-Pad2_ Net-_C1-Pad2_ Net-_C1-Pad1_ eSim_PNP
Q9 Net-_Q15-Pad2_ Net-_D2-Pad1_ Net-_D2-Pad2_ eSim_NPN
R6 Net-_D2-Pad1_ Net-_D1-Pad2_ 20k
Q8 Net-_J3-Pad1_ Net-_C1-Pad1_ Net-_Q15-Pad2_ eSim_NPN
R7 Net-_D2-Pad2_ Net-_Q15-Pad3_ 30
D2 Net-_D2-Pad1_ Net-_D2-Pad2_ eSim_Diode
J1 Net-_J1-Pad1_ Net-_J1-Pad2_ Net-_J1-Pad3_ jfet_p
Q2 Net-_J3-Pad1_ Net-_J1-Pad3_ Net-_Q1-Pad2_ eSim_NPN
J2 Net-_J1-Pad1_ Net-_J2-Pad2_ Net-_J2-Pad3_ jfet_p
Q1 Net-_J1-Pad3_ Net-_Q1-Pad2_ Net-_Q1-Pad3_ eSim_NPN
R5 Net-_D2-Pad2_ Net-_R4-Pad1_ 100
R4 Net-_R4-Pad1_ Net-_Q6-Pad3_ 2k
R3 Net-_C1-Pad1_ Net-_J2-Pad3_ 1.8k
Q6 Net-_C1-Pad1_ Net-_Q1-Pad2_ Net-_Q6-Pad3_ eSim_NPN
Q4 Net-_Q1-Pad2_ Net-_D2-Pad1_ Net-_D2-Pad2_ eSim_NPN
R1 Net-_R1-Pad1_ Net-_Q1-Pad3_ 2k
R2 Net-_D2-Pad2_ Net-_R1-Pad1_ 100
Q7 Net-_Q11-Pad1_ Net-_Q3-Pad3_ Net-_J3-Pad1_ eSim_PNP
Q5 Net-_Q3-Pad3_ Net-_Q3-Pad3_ Net-_J3-Pad1_ eSim_PNP
J3 Net-_J3-Pad1_ Net-_J3-Pad1_ Net-_J3-Pad3_ jfet_p
Q19 Net-_D3-Pad1_ Net-_Q19-Pad2_ Net-_Q19-Pad3_ eSim_PNP
R8 Net-_C1-Pad2_ Net-_Q16-Pad2_ 6k
Q16 Net-_Q14-Pad1_ Net-_Q16-Pad2_ Net-_C1-Pad2_ eSim_NPN
Q18 Net-_Q14-Pad1_ Net-_Q14-Pad1_ Net-_Q16-Pad2_ eSim_NPN
Q14 Net-_Q14-Pad1_ Net-_Q12-Pad1_ Net-_J3-Pad1_ eSim_PNP
Q20 Net-_Q14-Pad1_ Net-_Q20-Pad2_ Net-_Q19-Pad3_ eSim_NPN
D1 Net-_D1-Pad1_ Net-_D1-Pad2_ eSim_Diode
Q12 Net-_Q12-Pad1_ Net-_J3-Pad3_ Net-_D1-Pad1_ eSim_NPN
Q11 Net-_Q11-Pad1_ Net-_D1-Pad1_ Net-_D1-Pad2_ eSim_NPN
U2 Net-_D2-Pad2_ Net-_J3-Pad3_ zener
Q13 Net-_Q12-Pad1_ Net-_Q12-Pad1_ Net-_J3-Pad1_ eSim_PNP
.end
