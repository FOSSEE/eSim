.title KiCad schematic
Q4 Net-_R2-Pad1_ Net-_Q1-Pad1_ Net-_R5-Pad1_ eSim_NPN
U1 Net-_D3-Pad2_ Net-_D1-Pad2_ Net-_D2-Pad2_ Net-_D4-Pad2_ Net-_D6-Pad2_ Net-_D5-Pad2_ Net-_R5-Pad2_ Net-_D7-Pad2_ Net-_D8-Pad2_ Net-_D9-Pad2_ Net-_D12-Pad2_ Net-_D11-Pad2_ Net-_D10-Pad2_ Net-_R1-Pad2_ PORT
Q5 Net-_R3-Pad2_ Net-_R2-Pad1_ Net-_D3-Pad1_ eSim_NPN
Q6 Net-_D3-Pad2_ Net-_R5-Pad1_ Net-_R5-Pad2_ eSim_NPN
R3 Net-_R1-Pad2_ Net-_R3-Pad2_ 130
D3 Net-_D3-Pad1_ Net-_D3-Pad2_ eSim_Diode
D4 Net-_D4-Pad1_ Net-_D4-Pad2_ eSim_Diode
D2 Net-_R5-Pad2_ Net-_D2-Pad2_ eSim_Diode
Q3 Net-_R2-Pad1_ Net-_Q2-Pad1_ Net-_R5-Pad1_ eSim_NPN
R4 Net-_R4-Pad1_ Net-_R1-Pad2_ 4K
Q2 Net-_Q2-Pad1_ Net-_R4-Pad1_ Net-_D2-Pad2_ eSim_NPN
R2 Net-_R2-Pad1_ Net-_R1-Pad2_ 1.6K
R5 Net-_R5-Pad1_ Net-_R5-Pad2_ 1K
D1 Net-_R5-Pad2_ Net-_D1-Pad2_ eSim_Diode
Q1 Net-_Q1-Pad1_ Net-_R1-Pad1_ Net-_D1-Pad2_ eSim_NPN
R1 Net-_R1-Pad1_ Net-_R1-Pad2_ 4K
Q17 Net-_R13-Pad2_ Net-_R12-Pad1_ Net-_D9-Pad1_ eSim_NPN
D9 Net-_D9-Pad1_ Net-_D9-Pad2_ eSim_Diode
R13 Net-_R1-Pad2_ Net-_R13-Pad2_ 130
Q18 Net-_D9-Pad2_ Net-_R15-Pad1_ Net-_R5-Pad2_ eSim_NPN
Q15 Net-_R12-Pad1_ Net-_Q14-Pad1_ Net-_R15-Pad1_ eSim_NPN
Q14 Net-_Q14-Pad1_ Net-_R14-Pad1_ Net-_D8-Pad2_ eSim_NPN
R15 Net-_R15-Pad1_ Net-_R5-Pad2_ 1K
R11 Net-_R11-Pad1_ Net-_R1-Pad2_ 4K
R14 Net-_R14-Pad1_ Net-_R1-Pad2_ 4K
Q16 Net-_R12-Pad1_ Net-_Q13-Pad1_ Net-_R15-Pad1_ eSim_NPN
R12 Net-_R12-Pad1_ Net-_R1-Pad2_ 1.6K
D8 Net-_R5-Pad2_ Net-_D8-Pad2_ eSim_Diode
D7 Net-_R5-Pad2_ Net-_D7-Pad2_ eSim_Diode
Q13 Net-_Q13-Pad1_ Net-_R11-Pad1_ Net-_D7-Pad2_ eSim_NPN
Q7 Net-_R6-Pad2_ Net-_R7-Pad1_ Net-_D4-Pad1_ eSim_NPN
Q8 Net-_D4-Pad2_ Net-_R9-Pad1_ Net-_R5-Pad2_ eSim_NPN
R6 Net-_R1-Pad2_ Net-_R6-Pad2_ 130
R7 Net-_R7-Pad1_ Net-_R1-Pad2_ 1.6K
Q10 Net-_R7-Pad1_ Net-_Q10-Pad2_ Net-_R9-Pad1_ eSim_NPN
R9 Net-_R9-Pad1_ Net-_R5-Pad2_ 1K
D6 Net-_R5-Pad2_ Net-_D6-Pad2_ eSim_Diode
Q12 Net-_Q9-Pad2_ Net-_R8-Pad1_ Net-_D6-Pad2_ eSim_NPN
D5 Net-_R5-Pad2_ Net-_D5-Pad2_ eSim_Diode
Q11 Net-_Q10-Pad2_ Net-_R10-Pad1_ Net-_D5-Pad2_ eSim_NPN
Q9 Net-_R7-Pad1_ Net-_Q9-Pad2_ Net-_R9-Pad1_ eSim_NPN
R8 Net-_R8-Pad1_ Net-_R1-Pad2_ 4K
R10 Net-_R10-Pad1_ Net-_R1-Pad2_ 4K
Q20 Net-_D10-Pad2_ Net-_R19-Pad1_ Net-_R5-Pad2_ eSim_NPN
R19 Net-_R19-Pad1_ Net-_R5-Pad2_ 1K
D10 Net-_D10-Pad1_ Net-_D10-Pad2_ eSim_Diode
R17 Net-_R17-Pad1_ Net-_R1-Pad2_ 1.6K
Q19 Net-_R16-Pad2_ Net-_R17-Pad1_ Net-_D10-Pad1_ eSim_NPN
R16 Net-_R1-Pad2_ Net-_R16-Pad2_ 130
Q21 Net-_R17-Pad1_ Net-_Q21-Pad2_ Net-_R19-Pad1_ eSim_NPN
Q22 Net-_R17-Pad1_ Net-_Q22-Pad2_ Net-_R19-Pad1_ eSim_NPN
Q23 Net-_Q22-Pad2_ Net-_R20-Pad1_ Net-_D11-Pad2_ eSim_NPN
D11 Net-_R5-Pad2_ Net-_D11-Pad2_ eSim_Diode
R18 Net-_R18-Pad1_ Net-_R1-Pad2_ 4K
D12 Net-_R5-Pad2_ Net-_D12-Pad2_ eSim_Diode
Q24 Net-_Q21-Pad2_ Net-_R18-Pad1_ Net-_D12-Pad2_ eSim_NPN
R20 Net-_R20-Pad1_ Net-_R1-Pad2_ 4K
.end
