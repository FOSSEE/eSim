.title KiCad schematic
U1 Net-_Q2-Pad2_ Net-_Q1-Pad1_ Net-_Q1-Pad2_ Net-_D2-Pad2_ Net-_R2-Pad2_ Net-_Q1-Pad3_ Net-_Q3-Pad2_ Net-_R1-Pad1_ unconnected-_U1-Pad9_ Net-_Q3-Pad1_ Net-_Q2-Pad1_ Net-_R4-Pad1_ PORT
Q3 Net-_Q3-Pad1_ Net-_Q3-Pad2_ Net-_Q1-Pad1_ eSim_NPN
R4 Net-_R4-Pad1_ Net-_Q1-Pad2_ 5k
Q2 Net-_Q2-Pad1_ Net-_Q2-Pad2_ Net-_Q1-Pad1_ eSim_NPN
Q1 Net-_Q1-Pad1_ Net-_Q1-Pad2_ Net-_Q1-Pad3_ eSim_NPN
R5 Net-_D2-Pad2_ Net-_Q1-Pad2_ 2.8k
R2 Net-_R1-Pad1_ Net-_R2-Pad2_ 1k
R1 Net-_R1-Pad1_ Net-_D1-Pad2_ 2.2k
R3 Net-_R2-Pad2_ Net-_Q1-Pad3_ 500
D1 Net-_D1-Pad1_ Net-_D1-Pad2_ eSim_Diode
D2 Net-_D1-Pad1_ Net-_D2-Pad2_ eSim_Diode
.end
