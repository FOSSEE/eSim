.title KiCad schematic
Q9 Net-_Q6-Pad3_ Net-_Q6-Pad3_ Net-_C1-Pad1_ eSim_PNP
R4 Net-_Q6-Pad3_ Net-_C2-Pad2_ 24k
R2 Net-_Q6-Pad3_ Net-_Q10-Pad1_ 24k
U1 Net-_C1-Pad1_ Net-_R8-Pad1_ Net-_Q1-Pad3_ PORT
R5 Net-_Q13-Pad3_ Net-_Q12-Pad2_ 11.2k
Q13 Net-_C1-Pad1_ Net-_C1-Pad1_ Net-_Q13-Pad3_ eSim_NPN
C2 Net-_C2-Pad1_ Net-_C2-Pad2_ 30p
Q8 Net-_Q4-Pad2_ Net-_Q4-Pad2_ Net-_Q3-Pad2_ eSim_NPN
Q6 Net-_C2-Pad1_ Net-_C2-Pad2_ Net-_Q6-Pad3_ eSim_PNP
Q7 Net-_Q4-Pad2_ Net-_Q10-Pad1_ Net-_Q6-Pad3_ eSim_PNP
C1 Net-_C1-Pad1_ Net-_C1-Pad2_ 20p
R1 Net-_C1-Pad2_ Net-_C2-Pad1_ 10k
Q2 Net-_C1-Pad1_ Net-_C2-Pad1_ Net-_Q1-Pad2_ eSim_NPN
Q5 Net-_Q3-Pad2_ Net-_Q3-Pad2_ Net-_Q1-Pad3_ eSim_NPN
Q1 Net-_C1-Pad1_ Net-_Q1-Pad2_ Net-_Q1-Pad3_ eSim_NPN
Q4 Net-_C2-Pad1_ Net-_Q4-Pad2_ Net-_Q3-Pad2_ eSim_NPN
Q3 Net-_Q1-Pad2_ Net-_Q3-Pad2_ Net-_Q1-Pad3_ eSim_NPN
Q11 Net-_Q10-Pad3_ Net-_Q11-Pad2_ Net-_Q11-Pad3_ eSim_NPN
Q10 Net-_Q10-Pad1_ Net-_Q10-Pad2_ Net-_Q10-Pad3_ eSim_NPN
R3 Net-_Q11-Pad3_ Net-_Q1-Pad3_ 720
Q14 Net-_Q11-Pad2_ Net-_Q11-Pad2_ Net-_Q1-Pad3_ eSim_NPN
R7 Net-_Q10-Pad2_ Net-_Q11-Pad2_ 6.6k
R8 Net-_R8-Pad1_ Net-_Q10-Pad2_ 30k
R6 Net-_Q12-Pad2_ Net-_Q10-Pad2_ 500
Q12 Net-_C2-Pad2_ Net-_Q12-Pad2_ Net-_Q10-Pad3_ eSim_NPN
.end
