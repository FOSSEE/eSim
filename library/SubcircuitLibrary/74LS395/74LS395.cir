.title KiCad schematic
U30 Net-_U28-Pad6_ Net-_U29-Pad1_ d_inverter
U28 Net-_U26-Pad3_ Net-_U10-Pad2_ unconnected-_U28-Pad3_ Net-_U10-Pad4_ Net-_U1-Pad11_ Net-_U28-Pad6_ d_dff
U29 Net-_U29-Pad1_ Net-_U11-Pad2_ Net-_U1-Pad12_ d_tristate
U1 Net-_U1-Pad1_ Net-_U1-Pad2_ Net-_U1-Pad3_ Net-_U1-Pad4_ Net-_U1-Pad5_ Net-_U1-Pad6_ Net-_U1-Pad7_ unconnected-_U1-Pad8_ Net-_U1-Pad9_ Net-_U1-Pad10_ Net-_U1-Pad11_ Net-_U1-Pad12_ Net-_U1-Pad13_ Net-_U1-Pad14_ Net-_U1-Pad15_ unconnected-_U1-Pad16_ PORT
U22 Net-_U20-Pad3_ Net-_U10-Pad2_ unconnected-_U22-Pad3_ Net-_U10-Pad4_ Net-_U22-Pad5_ Net-_U22-Pad6_ d_dff
U24 Net-_U22-Pad6_ Net-_U23-Pad1_ d_inverter
U23 Net-_U23-Pad1_ Net-_U11-Pad2_ Net-_U1-Pad13_ d_tristate
U18 Net-_U16-Pad6_ Net-_U17-Pad1_ d_inverter
U17 Net-_U17-Pad1_ Net-_U11-Pad2_ Net-_U1-Pad14_ d_tristate
U27 Net-_U1-Pad6_ Net-_U15-Pad2_ Net-_U26-Pad1_ d_and
U26 Net-_U26-Pad1_ Net-_U25-Pad3_ Net-_U26-Pad3_ d_or
U25 Net-_U13-Pad1_ Net-_U22-Pad5_ Net-_U25-Pad3_ d_and
U15 Net-_U1-Pad4_ Net-_U15-Pad2_ Net-_U14-Pad1_ d_and
U14 Net-_U14-Pad1_ Net-_U13-Pad3_ Net-_U14-Pad3_ d_or
U13 Net-_U13-Pad1_ Net-_U10-Pad5_ Net-_U13-Pad3_ d_and
U21 Net-_U1-Pad5_ Net-_U15-Pad2_ Net-_U20-Pad1_ d_and
U20 Net-_U20-Pad1_ Net-_U19-Pad3_ Net-_U20-Pad3_ d_or
U19 Net-_U13-Pad1_ Net-_U16-Pad5_ Net-_U19-Pad3_ d_and
U16 Net-_U14-Pad3_ Net-_U10-Pad2_ unconnected-_U16-Pad3_ Net-_U10-Pad4_ Net-_U16-Pad5_ Net-_U16-Pad6_ d_dff
U10 Net-_U10-Pad1_ Net-_U10-Pad2_ unconnected-_U10-Pad3_ Net-_U10-Pad4_ Net-_U10-Pad5_ Net-_U10-Pad6_ d_dff
U8 Net-_U8-Pad1_ Net-_U7-Pad3_ Net-_U10-Pad1_ d_or
U12 Net-_U10-Pad6_ Net-_U11-Pad1_ d_inverter
U11 Net-_U11-Pad1_ Net-_U11-Pad2_ Net-_U1-Pad15_ d_tristate
U3 Net-_U1-Pad10_ Net-_U10-Pad2_ d_inverter
U6 Net-_U1-Pad1_ Net-_U10-Pad4_ d_inverter
U4 Net-_U1-Pad9_ Net-_U11-Pad2_ d_inverter
U7 Net-_U13-Pad1_ Net-_U1-Pad2_ Net-_U7-Pad3_ d_and
U5 Net-_U13-Pad1_ Net-_U15-Pad2_ d_inverter
U2 Net-_U1-Pad7_ Net-_U13-Pad1_ d_inverter
U9 Net-_U1-Pad3_ Net-_U15-Pad2_ Net-_U8-Pad1_ d_and
.end
