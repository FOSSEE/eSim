.title KiCad schematic
U29 Net-_U21-Pad3_ Net-_U18-Pad2_ Net-_U29-Pad3_ d_and
U21 Net-_U1-Pad9_ Net-_U19-Pad2_ Net-_U21-Pad3_ d_and
U30 Net-_U22-Pad3_ Net-_U18-Pad2_ Net-_U30-Pad3_ d_and
U31 Net-_U23-Pad3_ Net-_U18-Pad2_ Net-_U31-Pad3_ d_and
U22 Net-_U17-Pad2_ Net-_U1-Pad10_ Net-_U22-Pad3_ d_and
U18 Net-_U1-Pad11_ Net-_U18-Pad2_ d_inverter
U19 Net-_U1-Pad10_ Net-_U19-Pad2_ d_inverter
U34 Net-_U26-Pad3_ Net-_U1-Pad11_ Net-_U34-Pad3_ d_and
U33 Net-_U25-Pad3_ Net-_U1-Pad11_ Net-_U2-Pad2_ d_and
U32 Net-_U24-Pad3_ Net-_U1-Pad11_ Net-_U32-Pad3_ d_and
U35 Net-_U27-Pad3_ Net-_U1-Pad11_ Net-_U3-Pad2_ d_and
U1 Net-_U1-Pad1_ Net-_U1-Pad2_ Net-_U1-Pad3_ Net-_U1-Pad4_ Net-_U1-Pad5_ Net-_U1-Pad6_ Net-_U1-Pad7_ Net-_U1-Pad8_ Net-_U1-Pad9_ Net-_U1-Pad10_ Net-_U1-Pad11_ Net-_U1-Pad12_ PORT
U3 Net-_U1-Pad8_ Net-_U3-Pad2_ Net-_U13-Pad2_ d_and
U27 Net-_U1-Pad9_ Net-_U1-Pad10_ Net-_U27-Pad3_ d_and
U23 Net-_U1-Pad9_ Net-_U1-Pad10_ Net-_U23-Pad3_ d_and
U24 Net-_U17-Pad2_ Net-_U19-Pad2_ Net-_U24-Pad3_ d_and
U25 Net-_U1-Pad9_ Net-_U19-Pad2_ Net-_U25-Pad3_ d_and
U26 Net-_U17-Pad2_ Net-_U1-Pad10_ Net-_U26-Pad3_ d_and
U20 Net-_U17-Pad2_ Net-_U19-Pad2_ Net-_U20-Pad3_ d_and
U28 Net-_U20-Pad3_ Net-_U18-Pad2_ Net-_U1-Pad1_ d_and
U17 Net-_U1-Pad9_ Net-_U17-Pad2_ d_inverter
U15 Net-_U14-Pad3_ Net-_U15-Pad2_ Net-_U1-Pad12_ d_or
U16 Net-_U12-Pad3_ Net-_U13-Pad3_ Net-_U15-Pad2_ d_or
U13 Net-_U13-Pad1_ Net-_U13-Pad2_ Net-_U13-Pad3_ d_or
U14 Net-_U10-Pad3_ Net-_U11-Pad3_ Net-_U14-Pad3_ d_or
U4 Net-_U1-Pad7_ Net-_U34-Pad3_ Net-_U13-Pad1_ d_and
U9 Net-_U1-Pad5_ Net-_U32-Pad3_ Net-_U12-Pad1_ d_and
U2 Net-_U1-Pad6_ Net-_U2-Pad2_ Net-_U12-Pad2_ d_and
U7 Net-_U1-Pad1_ Net-_U1-Pad1_ Net-_U10-Pad1_ d_and
U5 Net-_U1-Pad2_ Net-_U29-Pad3_ Net-_U10-Pad2_ d_and
U10 Net-_U10-Pad1_ Net-_U10-Pad2_ Net-_U10-Pad3_ d_or
U12 Net-_U12-Pad1_ Net-_U12-Pad2_ Net-_U12-Pad3_ d_or
U11 Net-_U11-Pad1_ Net-_U11-Pad2_ Net-_U11-Pad3_ d_or
U6 Net-_U1-Pad3_ Net-_U30-Pad3_ Net-_U11-Pad1_ d_and
U8 Net-_U1-Pad4_ Net-_U31-Pad3_ Net-_U11-Pad2_ d_and
.end
