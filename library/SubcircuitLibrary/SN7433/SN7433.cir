.title KiCad schematic
.include NPN.lib
.include D.lib
D7 0 Net-_D7-Pad2_ 1N4148
D8 0 Net-_D8-Pad2_ 1N4148
Q10 Net-_Q10-Pad1_ Net-_Q10-Pad2_ Net-_D3-Pad2_ Q2N2222
D3 0 Net-_D3-Pad2_ 1N4148
D4 0 Net-_D4-Pad2_ 1N4148
Q7 Net-_Q7-Pad1_ Net-_Q7-Pad2_ Net-_Q6-Pad2_ Q2N2222
R5 Net-_Q7-Pad1_ VCC 660
R6 Net-_Q10-Pad2_ VCC 4k
Q9 Net-_Q7-Pad2_ Net-_Q9-Pad2_ Net-_D4-Pad2_ Q2N2222
R7 VCC Net-_Q9-Pad2_ 4k
R8 0 Net-_Q6-Pad2_ 250
Q8 Net-_Q7-Pad1_ Net-_Q10-Pad1_ Net-_Q6-Pad2_ Q2N2222
R13 Net-_Q17-Pad1_ Net-_R10-Pad2_ 660
Q18 Net-_Q17-Pad1_ Net-_Q18-Pad2_ Net-_Q16-Pad2_ Q2N2222
Q20 Net-_Q17-Pad2_ Net-_Q20-Pad2_ Net-_D7-Pad2_ Q2N2222
Q17 Net-_Q17-Pad1_ Net-_Q17-Pad2_ Net-_Q16-Pad2_ Q2N2222
R16 0 Net-_Q16-Pad2_ 250
R14 Net-_Q20-Pad2_ Net-_R10-Pad2_ 4k
R15 Net-_R10-Pad2_ Net-_Q19-Pad2_ 4k
Q19 Net-_Q18-Pad2_ Net-_Q19-Pad2_ Net-_D8-Pad2_ Q2N2222
R3 Net-_Q2-Pad1_ VCC 660
Q2 Net-_Q2-Pad1_ Net-_Q1-Pad1_ Net-_Q2-Pad3_ Q2N2222
Q4 Net-_Q2-Pad1_ Net-_Q3-Pad1_ Net-_Q2-Pad3_ Q2N2222
R4 0 Net-_Q2-Pad3_ 250
Q5 Net-_Q5-Pad1_ Net-_Q2-Pad3_ 0 Q2N2222
Q11 Net-_Q11-Pad1_ Net-_Q11-Pad2_ Net-_D5-Pad2_ Q2N2222
R9 Net-_R10-Pad2_ Net-_Q11-Pad2_ 4k
R10 Net-_Q12-Pad2_ Net-_R10-Pad2_ 4k
Q13 Net-_Q13-Pad1_ Net-_Q11-Pad1_ Net-_Q13-Pad3_ Q2N2222
D5 0 Net-_D5-Pad2_ 1N4148
D6 0 Net-_D6-Pad2_ 1N4148
Q14 Net-_Q13-Pad1_ Net-_Q12-Pad1_ Net-_Q13-Pad3_ Q2N2222
Q12 Net-_Q12-Pad1_ Net-_Q12-Pad2_ Net-_D6-Pad2_ Q2N2222
R11 Net-_Q13-Pad1_ Net-_R10-Pad2_ 660
R12 0 Net-_Q13-Pad3_ 250
Q16 Net-_Q16-Pad1_ Net-_Q16-Pad2_ 0 Q2N2222
Q15 Net-_Q15-Pad1_ Net-_Q13-Pad3_ 0 Q2N2222
R2 Net-_Q3-Pad2_ VCC 4k
R1 VCC Net-_Q1-Pad2_ 4k
Q3 Net-_Q3-Pad1_ Net-_Q3-Pad2_ Net-_D2-Pad2_ Q2N2222
Q1 Net-_Q1-Pad1_ Net-_Q1-Pad2_ Net-_D1-Pad2_ Q2N2222
D2 0 Net-_D2-Pad2_ 1N4148
D1 0 Net-_D1-Pad2_ 1N4148
Q6 Net-_Q6-Pad1_ Net-_Q6-Pad2_ 0 Q2N2222
VCC VCC 0 DC 5
.op
.end
