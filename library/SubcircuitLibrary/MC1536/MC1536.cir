.title KiCad schematic
U1 Net-_Q5-Pad3_ Net-_D1-Pad2_ Net-_D4-Pad2_ Net-_D7-Pad2_ Net-_Q8-Pad3_ Net-_D10-Pad2_ Net-_J1-Pad1_ unconnected-_U1-Pad8_ PORT
Q1 Net-_Q1-Pad1_ Net-_D1-Pad2_ Net-_D1-Pad1_ eSim_NPN
Q4 Net-_Q4-Pad1_ Net-_D1-Pad1_ Net-_Q4-Pad3_ eSim_PNP
D1 Net-_D1-Pad1_ Net-_D1-Pad2_ eSim_Diode
Q2 Net-_D1-Pad1_ Net-_Q11-Pad2_ Net-_Q2-Pad3_ eSim_NPN
Q3 Net-_Q2-Pad3_ Net-_D7-Pad1_ Net-_Q3-Pad3_ eSim_NPN
Q9 Net-_C1-Pad1_ Net-_D4-Pad1_ Net-_Q9-Pad3_ eSim_PNP
D4 Net-_D4-Pad1_ Net-_D4-Pad2_ eSim_Diode
Q10 Net-_Q10-Pad1_ Net-_D4-Pad2_ Net-_D4-Pad1_ eSim_NPN
U3 Net-_D7-Pad2_ Net-_D5-Pad2_ zener
U2 Net-_D7-Pad2_ Net-_D5-Pad1_ zener
Q14 Net-_Q13-Pad2_ Net-_D5-Pad2_ Net-_D6-Pad1_ eSim_NPN
R10 Net-_D7-Pad2_ Net-_Q12-Pad3_ 7.7K
Q5 Net-_Q4-Pad1_ Net-_Q5-Pad2_ Net-_Q5-Pad3_ eSim_NPN
R5 Net-_D7-Pad2_ Net-_Q5-Pad2_ 39K
R9 Net-_D7-Pad2_ Net-_Q8-Pad3_ 1.0K
Q8 Net-_C1-Pad1_ Net-_Q5-Pad2_ Net-_Q8-Pad3_ eSim_NPN
R4 Net-_D7-Pad2_ Net-_Q5-Pad3_ 1.0K
R1 Net-_D7-Pad2_ Net-_Q3-Pad3_ 7.7K
Q6 Net-_Q16-Pad3_ Net-_Q4-Pad1_ Net-_Q5-Pad2_ eSim_NPN
D5 Net-_D5-Pad1_ Net-_D5-Pad2_ eSim_Diode
J1 Net-_J1-Pad1_ Net-_D7-Pad2_ Net-_D5-Pad1_ jfet_n
D3 Net-_D2-Pad1_ Net-_D3-Pad2_ eSim_Diode
R3 Net-_Q4-Pad3_ Net-_Q1-Pad1_ 1.5K
R2 Net-_Q1-Pad1_ Net-_D2-Pad2_ 500
R7 Net-_Q10-Pad1_ Net-_D3-Pad2_ 500
R8 Net-_Q9-Pad3_ Net-_Q10-Pad1_ 1.5K
R6 Net-_Q7-Pad3_ Net-_J1-Pad1_ 6K
R11 Net-_Q13-Pad3_ Net-_J1-Pad1_ 1.5K
Q13 Net-_D5-Pad2_ Net-_Q13-Pad2_ Net-_Q13-Pad3_ eSim_PNP
D2 Net-_D2-Pad1_ Net-_D2-Pad2_ eSim_Diode
Q7 Net-_D2-Pad1_ Net-_Q13-Pad2_ Net-_Q7-Pad3_ eSim_PNP
Q12 Net-_Q11-Pad3_ Net-_D7-Pad1_ Net-_Q12-Pad3_ eSim_NPN
Q11 Net-_D4-Pad1_ Net-_Q11-Pad2_ Net-_Q11-Pad3_ eSim_NPN
R12 Net-_Q15-Pad3_ Net-_J1-Pad1_ 1.0k
Q15 Net-_Q13-Pad2_ Net-_Q13-Pad2_ Net-_Q15-Pad3_ eSim_PNP
R25 Net-_Q27-Pad3_ Net-_Q26-Pad3_ 15K
Q28 Net-_Q27-Pad3_ Net-_Q20-Pad1_ Net-_Q28-Pad3_ eSim_NPN
Q27 Net-_J1-Pad1_ Net-_Q26-Pad3_ Net-_Q27-Pad3_ eSim_NPN
R24 Net-_D10-Pad2_ Net-_Q26-Pad2_ 28K
Q26 Net-_J1-Pad1_ Net-_Q26-Pad2_ Net-_Q26-Pad3_ eSim_NPN
R23 Net-_Q26-Pad2_ Net-_J1-Pad1_ 28K
R26 Net-_D10-Pad2_ Net-_Q28-Pad3_ 26
Q29 Net-_D7-Pad2_ Net-_Q25-Pad3_ Net-_Q29-Pad3_ eSim_PNP
R27 Net-_Q29-Pad3_ Net-_D10-Pad2_ 22
Q25 Net-_D7-Pad2_ Net-_C1-Pad2_ Net-_Q25-Pad3_ eSim_PNP
Q24 Net-_Q24-Pad1_ Net-_Q22-Pad3_ Net-_Q24-Pad3_ eSim_NPN
R22 Net-_D7-Pad2_ Net-_Q24-Pad3_ 50
Q23 Net-_C1-Pad2_ Net-_Q11-Pad2_ Net-_Q23-Pad3_ eSim_NPN
R21 Net-_Q24-Pad1_ Net-_Q23-Pad3_ 500
Q22 Net-_Q22-Pad1_ Net-_C1-Pad1_ Net-_Q22-Pad3_ eSim_NPN
R19 Net-_Q22-Pad1_ Net-_Q16-Pad3_ 5K
R20 Net-_D7-Pad2_ Net-_Q22-Pad3_ 39K
D9 Net-_D8-Pad2_ Net-_C1-Pad2_ eSim_Diode
C1 Net-_C1-Pad1_ Net-_C1-Pad2_ 35p
D8 Net-_D10-Pad1_ Net-_D8-Pad2_ eSim_Diode
D11 Net-_D10-Pad2_ Net-_D10-Pad1_ eSim_Diode
D10 Net-_D10-Pad1_ Net-_D10-Pad2_ eSim_Diode
Q20 Net-_Q20-Pad1_ Net-_Q20-Pad2_ Net-_D10-Pad1_ eSim_NPN
R18 Net-_Q20-Pad1_ Net-_Q20-Pad2_ 200
Q19 Net-_Q18-Pad2_ Net-_Q13-Pad2_ Net-_Q19-Pad3_ eSim_PNP
Q21 Net-_Q20-Pad2_ Net-_Q13-Pad2_ Net-_Q21-Pad3_ eSim_PNP
R17 Net-_Q21-Pad3_ Net-_J1-Pad1_ 1.2K
R16 Net-_Q19-Pad3_ Net-_J1-Pad1_ 12K
Q18 Net-_J1-Pad1_ Net-_Q18-Pad2_ Net-_Q16-Pad1_ eSim_NPN
R15 Net-_D7-Pad2_ Net-_Q11-Pad2_ 39K
D6 Net-_D6-Pad1_ Net-_D6-Pad2_ eSim_Diode
R14 Net-_D7-Pad1_ Net-_Q17-Pad2_ 3.5K
Q16 Net-_Q16-Pad1_ Net-_D6-Pad1_ Net-_Q16-Pad3_ eSim_NPN
R13 Net-_Q17-Pad2_ Net-_D6-Pad2_ 4.7K
Q17 Net-_Q16-Pad3_ Net-_Q17-Pad2_ Net-_Q11-Pad2_ eSim_NPN
D7 Net-_D7-Pad1_ Net-_D7-Pad2_ eSim_Diode
.end
