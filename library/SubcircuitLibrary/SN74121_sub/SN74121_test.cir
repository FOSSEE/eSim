.title KiCad schematic
v3 Net-_U1-Pad3_ GND pulse
v1 Net-_U1-Pad1_ GND pulse
U2 Net-_U2-Pad1_ Net-_U2-Pad2_ Net-_U5-Pad~_ Net-_U6-Pad~_ dac_bridge_2
X1 Net-_U1-Pad5_ Net-_U1-Pad6_ Net-_U1-Pad7_ Net-_U2-Pad1_ Net-_U2-Pad2_ SN74121
U6 Net-_U6-Pad~_ plot_v1
U5 Net-_U5-Pad~_ plot_v1
U1 Net-_U1-Pad1_ Net-_U1-Pad2_ Net-_U1-Pad3_ Net-_U1-Pad3_ Net-_U1-Pad5_ Net-_U1-Pad6_ Net-_U1-Pad7_ unconnected-_U1-Pad8_ adc_bridge_4
v2 Net-_U1-Pad2_ GND pulse
.end
