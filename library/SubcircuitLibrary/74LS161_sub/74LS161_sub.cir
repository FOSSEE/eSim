.title KiCad schematic
U7 Net-_U1-Pad1_ Net-_U3-Pad1_ Net-_U7-Pad3_ d_and
U9 Net-_U7-Pad3_ Net-_U13-Pad1_ d_inverter
U10 Net-_U1-Pad1_ Net-_U1-Pad2_ Net-_U10-Pad3_ d_and
U12 Net-_U10-Pad3_ Net-_U1-Pad3_ Net-_U12-Pad3_ d_and
U13 Net-_U13-Pad1_ Net-_U1-Pad2_ Net-_U1-Pad6_ d_or
U8 Net-_U1-Pad1_ Net-_U1-Pad2_ Net-_U11-Pad1_ d_and
U11 Net-_U11-Pad1_ Net-_U11-Pad2_ Net-_U11-Pad3_ d_and
U3 Net-_U3-Pad1_ Net-_U1-Pad5_ Net-_U1-Pad6_ Net-_U1-Pad6_ Net-_U1-Pad2_ unconnected-_U3-Pad6_ d_dff
U4 Net-_U18-Pad3_ Net-_U1-Pad5_ Net-_U1-Pad6_ Net-_U1-Pad6_ Net-_U1-Pad4_ unconnected-_U4-Pad6_ d_dff
U5 Net-_U11-Pad2_ Net-_U1-Pad5_ Net-_U1-Pad6_ Net-_U1-Pad6_ Net-_U1-Pad3_ unconnected-_U5-Pad6_ d_dff
U1 Net-_U1-Pad1_ Net-_U1-Pad2_ Net-_U1-Pad3_ Net-_U1-Pad4_ Net-_U1-Pad5_ Net-_U1-Pad6_ PORT
U2 Net-_U2-Pad1_ Net-_U1-Pad5_ Net-_U1-Pad6_ Net-_U1-Pad6_ Net-_U1-Pad1_ unconnected-_U2-Pad6_ d_dff
U6 Net-_U1-Pad1_ Net-_U2-Pad1_ d_inverter
U15 Net-_U14-Pad2_ Net-_U1-Pad3_ Net-_U11-Pad2_ d_or
U14 Net-_U11-Pad3_ Net-_U14-Pad2_ d_inverter
U17 Net-_U16-Pad3_ Net-_U17-Pad2_ d_inverter
U16 Net-_U12-Pad3_ Net-_U1-Pad4_ Net-_U16-Pad3_ d_and
U18 Net-_U17-Pad2_ Net-_U1-Pad4_ Net-_U18-Pad3_ d_or
.end
