.title KiCad schematic
U4 Net-_U3-Pad2_ Net-_U4-Pad2_ d_inverter
U3 Net-_U2-Pad2_ Net-_U3-Pad2_ d_inverter
U2 Net-_U1-Pad1_ Net-_U2-Pad2_ d_inverter
U1 Net-_U1-Pad1_ Net-_U1-Pad2_ PORT
U7 Net-_U6-Pad2_ Net-_U1-Pad2_ d_inverter
U5 Net-_U4-Pad2_ Net-_U5-Pad2_ d_inverter
U6 Net-_U5-Pad2_ Net-_U6-Pad2_ d_inverter
.end
