.title KiCad schematic
U2 Net-_U1-Pad4_ Net-_U2-Pad2_ d_inverter
U3 Net-_U1-Pad3_ Net-_U3-Pad2_ d_buffer
U5 Net-_U2-Pad2_ Net-_U3-Pad2_ Net-_U5-Pad3_ d_and
U4 Net-_U1-Pad3_ Net-_U1-Pad2_ Net-_U4-Pad3_ d_xor
U1 Net-_U1-Pad1_ Net-_U1-Pad2_ Net-_U1-Pad3_ Net-_U1-Pad4_ Net-_U1-Pad5_ Net-_U1-Pad2_ Net-_U1-Pad7_ Net-_U1-Pad8_ PORT
U6 Net-_U1-Pad2_ Net-_U6-Pad2_ d_buffer
U9 Net-_U5-Pad3_ Net-_U6-Pad2_ Net-_U1-Pad8_ d_and
U7 Net-_U1-Pad1_ Net-_U1-Pad5_ d_inverter
U8 Net-_U2-Pad2_ Net-_U4-Pad3_ Net-_U1-Pad7_ d_and
.end
