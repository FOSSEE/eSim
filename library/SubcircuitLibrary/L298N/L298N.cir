.title KiCad schematic
Q3 /VCC_Motor Net-_Q3-Pad2_ /OUT_A eSim_NPN
R1 Net-_A1-Pad6_ Net-_Q3-Pad2_ 1K
D2 /OUT_A /VCC_Motor D1N4002_PSPICE
D1 /GND /OUT_A D1N4002_PSPICE
A2 unconnected-_A2-Pad1_ /ENA unconnected-_A2-Pad3_ /IN2 unconnected-_A2-Pad5_ Net-_A2-Pad6_ unconnected-_A2-Pad7_ unconnected-_A2-Pad8_ and
A1 unconnected-_A1-Pad1_ /ENA unconnected-_A1-Pad3_ /IN1 unconnected-_A1-Pad5_ Net-_A1-Pad6_ unconnected-_A1-Pad7_ unconnected-_A1-Pad8_ and
Q4 /OUT_A Net-_Q4-Pad2_ /GND eSim_NPN
R2 Net-_A2-Pad6_ Net-_Q4-Pad2_ 1K
Q2 /OUT_C Net-_Q7-Pad2_ /GND eSim_NPN
R4 Net-_A3-Pad6_ Net-_Q1-Pad2_ 1k
Q1 /VCC_Motor Net-_Q1-Pad2_ /OUT_C eSim_NPN
A3 unconnected-_A3-Pad1_ /ENB unconnected-_A3-Pad3_ /IN3 unconnected-_A3-Pad5_ Net-_A3-Pad6_ unconnected-_A3-Pad7_ unconnected-_A3-Pad8_ and
D6 /OUT_C /VCC_Motor D1N4002_PSPICE
D5 /GND /OUT_C D1N4002_PSPICE
A4 unconnected-_A4-Pad1_ /ENB unconnected-_A4-Pad3_ /IN4 unconnected-_A4-Pad5_ Net-_R3-Pad1_ unconnected-_A4-Pad7_ unconnected-_A4-Pad8_ and
R3 Net-_R3-Pad1_ Net-_Q7-Pad2_ 1K
Q6 /OUT_B Net-_Q3-Pad2_ /GND eSim_NPN
D4 /GND /OUT_B D1N4002_PSPICE
Q5 /VCC_Motor Net-_Q4-Pad2_ /OUT_B eSim_NPN
D3 /OUT_B /VCC_Motor D1N4002_PSPICE
D7 /OUT_D /VCC_Motor D1N4002_PSPICE
D8 /GND /OUT_D D1N4002_PSPICE
Q8 /OUT_D Net-_Q1-Pad2_ /GND eSim_NPN
Q7 /VCC_Motor Net-_Q7-Pad2_ /OUT_D eSim_NPN
.end
