.title KiCad schematic
R6 Net-_R3-Pad1_ Net-_Q5-Pad2_ 1K
Q6 Net-_Q6-Pad1_ Net-_Q6-Pad2_ Net-_Q5-Pad2_ eSim_NPN
R5 Net-_Q7-Pad2_ Net-_R1-Pad2_ 4K
R4 Net-_Q6-Pad1_ Net-_R1-Pad2_ 1.8K
R10 Net-_Q14-Pad1_ Net-_R1-Pad2_ 1.8K
R11 Net-_Q15-Pad2_ Net-_R1-Pad2_ 4K
D4 Net-_R3-Pad1_ Net-_D4-Pad2_ eSim_Diode
U1 Net-_Q4-Pad1_ Net-_D1-Pad2_ Net-_D2-Pad2_ Net-_Q5-Pad1_ Net-_D4-Pad2_ Net-_D3-Pad2_ Net-_R3-Pad1_ Net-_D5-Pad2_ Net-_D6-Pad2_ Net-_Q12-Pad1_ Net-_D8-Pad2_ Net-_D7-Pad2_ Net-_Q13-Pad1_ Net-_R1-Pad2_ PORT
Q7 Net-_Q6-Pad2_ Net-_Q7-Pad2_ Net-_D3-Pad2_ eSim_NPN
D3 Net-_R3-Pad1_ Net-_D3-Pad2_ eSim_Diode
Q8 Net-_Q6-Pad2_ Net-_Q7-Pad2_ Net-_D4-Pad2_ eSim_NPN
Q15 Net-_Q14-Pad2_ Net-_Q15-Pad2_ Net-_D7-Pad2_ eSim_NPN
R12 Net-_R3-Pad1_ Net-_Q13-Pad2_ 1K
Q14 Net-_Q14-Pad1_ Net-_Q14-Pad2_ Net-_Q13-Pad2_ eSim_NPN
D7 Net-_R3-Pad1_ Net-_D7-Pad2_ eSim_Diode
D8 Net-_R3-Pad1_ Net-_D8-Pad2_ eSim_Diode
Q16 Net-_Q14-Pad2_ Net-_Q15-Pad2_ Net-_D8-Pad2_ eSim_NPN
Q13 Net-_Q13-Pad1_ Net-_Q13-Pad2_ Net-_R3-Pad1_ eSim_NPN
Q12 Net-_Q12-Pad1_ Net-_Q11-Pad3_ Net-_R3-Pad1_ eSim_NPN
Q5 Net-_Q5-Pad1_ Net-_Q5-Pad2_ Net-_R3-Pad1_ eSim_NPN
Q4 Net-_Q4-Pad1_ Net-_R3-Pad2_ Net-_R3-Pad1_ eSim_NPN
Q3 Net-_R2-Pad1_ Net-_Q1-Pad1_ Net-_R3-Pad2_ eSim_NPN
R3 Net-_R3-Pad1_ Net-_R3-Pad2_ 1K
R1 Net-_R1-Pad1_ Net-_R1-Pad2_ 4K
R2 Net-_R2-Pad1_ Net-_R1-Pad2_ 1.8K
D1 Net-_R3-Pad1_ Net-_D1-Pad2_ eSim_Diode
D2 Net-_R3-Pad1_ Net-_D2-Pad2_ eSim_Diode
Q2 Net-_Q1-Pad1_ Net-_R1-Pad1_ Net-_D2-Pad2_ eSim_NPN
Q1 Net-_Q1-Pad1_ Net-_R1-Pad1_ Net-_D1-Pad2_ eSim_NPN
Q10 Net-_Q9-Pad1_ Net-_Q9-Pad2_ Net-_D6-Pad2_ eSim_NPN
Q11 Net-_Q11-Pad1_ Net-_Q9-Pad1_ Net-_Q11-Pad3_ eSim_NPN
R9 Net-_R3-Pad1_ Net-_Q11-Pad3_ 1K
R8 Net-_Q11-Pad1_ Net-_R1-Pad2_ 1.8K
R7 Net-_Q9-Pad2_ Net-_R1-Pad2_ 4K
D6 Net-_R3-Pad1_ Net-_D6-Pad2_ eSim_Diode
Q9 Net-_Q9-Pad1_ Net-_Q9-Pad2_ Net-_D5-Pad2_ eSim_NPN
D5 Net-_R3-Pad1_ Net-_D5-Pad2_ eSim_Diode
.end
