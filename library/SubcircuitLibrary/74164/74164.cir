.title KiCad schematic
U12 Net-_U2-Pad1_ Net-_U12-Pad2_ d_inverter
U20 Net-_U1-Pad1_ Net-_U1-Pad2_ Net-_U5-Pad5_ Net-_U7-Pad5_ Net-_U9-Pad5_ Net-_U11-Pad5_ Net-_U3-Pad1_ Net-_U4-Pad1_ Net-_U13-Pad5_ Net-_U15-Pad5_ Net-_U17-Pad5_ Net-_U19-Pad5_ PORT
U11 Net-_U9-Pad5_ Net-_U10-Pad2_ unconnected-_U11-Pad3_ Net-_U4-Pad2_ Net-_U11-Pad5_ unconnected-_U11-Pad6_ d_dff
U10 Net-_U2-Pad1_ Net-_U10-Pad2_ d_inverter
U13 Net-_U11-Pad5_ Net-_U12-Pad2_ unconnected-_U13-Pad3_ Net-_U4-Pad2_ Net-_U13-Pad5_ unconnected-_U13-Pad6_ d_dff
U2 Net-_U2-Pad1_ Net-_U2-Pad2_ d_inverter
U5 Net-_U1-Pad3_ Net-_U2-Pad2_ unconnected-_U5-Pad3_ Net-_U4-Pad2_ Net-_U5-Pad5_ unconnected-_U5-Pad6_ d_dff
U3 Net-_U3-Pad1_ Net-_U2-Pad1_ d_inverter
U4 Net-_U4-Pad1_ Net-_U4-Pad2_ d_inverter
U1 Net-_U1-Pad1_ Net-_U1-Pad2_ Net-_U1-Pad3_ d_and
U14 Net-_U2-Pad1_ Net-_U14-Pad2_ d_inverter
U15 Net-_U13-Pad5_ Net-_U14-Pad2_ unconnected-_U15-Pad3_ Net-_U4-Pad2_ Net-_U15-Pad5_ unconnected-_U15-Pad6_ d_dff
U16 Net-_U2-Pad1_ Net-_U16-Pad2_ d_inverter
U17 Net-_U15-Pad5_ Net-_U16-Pad2_ unconnected-_U17-Pad3_ Net-_U4-Pad2_ Net-_U17-Pad5_ unconnected-_U17-Pad6_ d_dff
U18 Net-_U2-Pad1_ Net-_U18-Pad2_ d_inverter
U19 Net-_U17-Pad5_ Net-_U18-Pad2_ unconnected-_U19-Pad3_ Net-_U4-Pad2_ Net-_U19-Pad5_ unconnected-_U19-Pad6_ d_dff
U6 Net-_U2-Pad1_ Net-_U6-Pad2_ d_inverter
U7 Net-_U5-Pad5_ Net-_U6-Pad2_ unconnected-_U7-Pad3_ Net-_U4-Pad2_ Net-_U7-Pad5_ unconnected-_U7-Pad6_ d_dff
U8 Net-_U2-Pad1_ Net-_U8-Pad2_ d_inverter
U9 Net-_U7-Pad5_ Net-_U8-Pad2_ unconnected-_U9-Pad3_ Net-_U4-Pad2_ Net-_U9-Pad5_ unconnected-_U9-Pad6_ d_dff
.end
