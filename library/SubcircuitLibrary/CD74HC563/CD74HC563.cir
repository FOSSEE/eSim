.title KiCad schematic
U2 Net-_U1-Pad1_ Net-_U10-Pad2_ d_inverter
U1 Net-_U1-Pad1_ Net-_U1-Pad2_ Net-_U1-Pad3_ Net-_U1-Pad4_ Net-_U1-Pad5_ Net-_U1-Pad6_ Net-_U1-Pad7_ Net-_U1-Pad8_ Net-_U1-Pad9_ Net-_U1-Pad11_ Net-_U1-Pad12_ Net-_U1-Pad13_ Net-_U1-Pad14_ Net-_U1-Pad15_ Net-_U1-Pad16_ Net-_U1-Pad17_ Net-_U1-Pad18_ Net-_U1-Pad19_ PORT
U5 Net-_U1-Pad3_ Net-_U1-Pad11_ unconnected-_U5-Pad3_ unconnected-_U5-Pad4_ Net-_U5-Pad5_ unconnected-_U5-Pad6_ d_dlatch
U4 Net-_U3-Pad5_ Net-_U10-Pad2_ Net-_U1-Pad19_ d_tristate
U3 Net-_U1-Pad2_ Net-_U1-Pad11_ unconnected-_U3-Pad3_ unconnected-_U3-Pad4_ Net-_U3-Pad5_ unconnected-_U3-Pad6_ d_dlatch
U13 Net-_U1-Pad7_ Net-_U1-Pad11_ unconnected-_U13-Pad3_ unconnected-_U13-Pad4_ Net-_U13-Pad5_ unconnected-_U13-Pad6_ d_dlatch
U15 Net-_U1-Pad8_ Net-_U1-Pad11_ unconnected-_U15-Pad3_ unconnected-_U15-Pad4_ Net-_U15-Pad5_ unconnected-_U15-Pad6_ d_dlatch
U11 Net-_U1-Pad6_ Net-_U1-Pad11_ unconnected-_U11-Pad3_ unconnected-_U11-Pad4_ Net-_U11-Pad5_ unconnected-_U11-Pad6_ d_dlatch
U12 Net-_U11-Pad5_ Net-_U10-Pad2_ Net-_U1-Pad15_ d_tristate
U10 Net-_U10-Pad1_ Net-_U10-Pad2_ Net-_U1-Pad16_ d_tristate
U14 Net-_U13-Pad5_ Net-_U10-Pad2_ Net-_U1-Pad14_ d_tristate
U8 Net-_U7-Pad5_ Net-_U10-Pad2_ Net-_U1-Pad17_ d_tristate
U6 Net-_U5-Pad5_ Net-_U10-Pad2_ Net-_U1-Pad18_ d_tristate
U7 Net-_U1-Pad4_ Net-_U1-Pad11_ unconnected-_U7-Pad3_ unconnected-_U7-Pad4_ Net-_U7-Pad5_ unconnected-_U7-Pad6_ d_dlatch
U9 Net-_U1-Pad5_ Net-_U1-Pad11_ unconnected-_U9-Pad3_ unconnected-_U9-Pad4_ Net-_U10-Pad1_ unconnected-_U9-Pad6_ d_dlatch
U17 Net-_U1-Pad9_ Net-_U1-Pad11_ unconnected-_U17-Pad3_ unconnected-_U17-Pad4_ Net-_U17-Pad5_ unconnected-_U17-Pad6_ d_dlatch
U16 Net-_U15-Pad5_ Net-_U10-Pad2_ Net-_U1-Pad13_ d_tristate
U18 Net-_U17-Pad5_ Net-_U10-Pad2_ Net-_U1-Pad12_ d_tristate
.end
