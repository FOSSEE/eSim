.title KiCad schematic
U14 Net-_U14-Pad1_ Net-_U11-Pad3_ Net-_U12-Pad1_ d_or
U1 Net-_U1-Pad1_ Net-_U1-Pad2_ Net-_U1-Pad3_ Net-_U1-Pad4_ Net-_U1-Pad5_ Net-_U1-Pad6_ Net-_U1-Pad7_ unconnected-_U1-Pad8_ Net-_U1-Pad9_ Net-_U1-Pad10_ Net-_U1-Pad11_ Net-_U1-Pad12_ Net-_U1-Pad13_ Net-_U1-Pad14_ Net-_U1-Pad15_ unconnected-_U1-Pad16_ PORT
U12 Net-_U12-Pad1_ Net-_U1-Pad2_ unconnected-_U12-Pad3_ unconnected-_U12-Pad4_ Net-_U1-Pad14_ Net-_U12-Pad6_ d_dff
U13 Net-_U1-Pad3_ Net-_U13-Pad2_ Net-_U11-Pad1_ d_and
U7 Net-_U18-Pad1_ Net-_U1-Pad11_ d_inverter
U26 Net-_U1-Pad4_ Net-_U13-Pad2_ Net-_U23-Pad1_ d_and
U3 Net-_U1-Pad7_ Net-_U3-Pad2_ d_inverter
U8 Net-_U1-Pad10_ Net-_U67-Pad1_ d_inverter
U9 Net-_U3-Pad2_ Net-_U4-Pad2_ Net-_U10-Pad1_ d_and
U4 Net-_U1-Pad10_ Net-_U4-Pad2_ d_inverter
U6 Net-_U13-Pad2_ Net-_U6-Pad2_ d_inverter
U5 Net-_U1-Pad9_ Net-_U13-Pad2_ d_inverter
U2 Net-_U1-Pad1_ Net-_U18-Pad1_ d_inverter
X2 Net-_U15-Pad2_ Net-_U6-Pad2_ Net-_U10-Pad1_ Net-_U14-Pad1_ 3_and
U15 Net-_U1-Pad14_ Net-_U15-Pad2_ d_inverter
U10 Net-_U10-Pad1_ Net-_U10-Pad2_ d_inverter
X1 Net-_U1-Pad14_ Net-_U10-Pad2_ Net-_U6-Pad2_ Net-_U11-Pad2_ 3_and
U11 Net-_U11-Pad1_ Net-_U11-Pad2_ Net-_U11-Pad3_ d_or
U61 Net-_U10-Pad1_ Net-_U1-Pad14_ Net-_U61-Pad3_ d_and
U68 Net-_U68-Pad1_ Net-_U68-Pad2_ Net-_U68-Pad3_ d_and
U67 Net-_U67-Pad1_ Net-_U67-Pad2_ Net-_U67-Pad3_ d_and
U69 Net-_U68-Pad3_ Net-_U67-Pad3_ Net-_U1-Pad15_ d_nor
X23 Net-_U18-Pad1_ Net-_U12-Pad6_ Net-_U25-Pad6_ Net-_U68-Pad1_ 3_and
X25 Net-_U1-Pad11_ Net-_U1-Pad11_ Net-_U1-Pad14_ Net-_U67-Pad2_ 3_and
X24 Net-_U20-Pad2_ Net-_U20-Pad1_ Net-_U67-Pad1_ Net-_U68-Pad2_ 3_and
U62 Net-_U61-Pad3_ Net-_U62-Pad2_ d_inverter
U64 Net-_U1-Pad11_ Net-_U64-Pad2_ d_inverter
U65 Net-_U65-Pad1_ Net-_U65-Pad2_ Net-_U60-Pad1_ d_and
U66 Net-_U1-Pad14_ Net-_U66-Pad2_ Net-_U65-Pad1_ d_and
X22 Net-_U1-Pad13_ Net-_U1-Pad12_ Net-_U10-Pad1_ Net-_U66-Pad2_ 3_and
X21 Net-_U1-Pad11_ Net-_U6-Pad2_ Net-_U64-Pad2_ Net-_U65-Pad2_ 3_and
X20 Net-_U6-Pad2_ Net-_U62-Pad2_ Net-_U1-Pad11_ Net-_U63-Pad2_ 3_and
U63 Net-_U1-Pad11_ Net-_U63-Pad2_ Net-_U56-Pad1_ d_and
U40 Net-_U40-Pad1_ Net-_U1-Pad2_ unconnected-_U40-Pad3_ unconnected-_U40-Pad4_ Net-_U1-Pad12_ Net-_U20-Pad2_ d_dff
U36 Net-_U36-Pad1_ Net-_U35-Pad3_ Net-_U36-Pad3_ d_or
U35 Net-_U35-Pad1_ Net-_U34-Pad3_ Net-_U35-Pad3_ d_or
U37 Net-_U37-Pad1_ Net-_U37-Pad2_ Net-_U35-Pad1_ d_and
U42 Net-_U42-Pad1_ Net-_U39-Pad3_ Net-_U40-Pad1_ d_or
U39 Net-_U39-Pad1_ Net-_U36-Pad3_ Net-_U39-Pad3_ d_or
X11 Net-_U1-Pad13_ Net-_U6-Pad2_ Net-_U1-Pad11_ Net-_U37-Pad2_ 3_and
X12 Net-_U38-Pad2_ Net-_U10-Pad1_ Net-_U1-Pad14_ Net-_U37-Pad1_ 3_and
U38 Net-_U1-Pad12_ Net-_U38-Pad2_ d_inverter
U33 Net-_U33-Pad1_ Net-_U33-Pad2_ d_inverter
X10 Net-_U1-Pad11_ Net-_U6-Pad2_ Net-_U33-Pad2_ Net-_U34-Pad2_ 3_and
U57 Net-_U57-Pad1_ Net-_U1-Pad2_ unconnected-_U57-Pad3_ unconnected-_U57-Pad4_ Net-_U1-Pad11_ Net-_U51-Pad1_ d_dff
U48 Net-_U10-Pad1_ Net-_U12-Pad6_ Net-_U48-Pad3_ d_and
U49 Net-_U48-Pad3_ Net-_U49-Pad2_ d_inverter
X13 Net-_U10-Pad1_ Net-_U12-Pad6_ Net-_U25-Pad6_ Net-_U43-Pad1_ 3_and
U43 Net-_U43-Pad1_ Net-_U43-Pad2_ d_inverter
X14 Net-_U6-Pad2_ Net-_U43-Pad2_ Net-_U1-Pad12_ Net-_U44-Pad2_ 3_and
U45 Net-_U1-Pad12_ Net-_U45-Pad2_ d_inverter
X15 Net-_U10-Pad1_ Net-_U18-Pad1_ Net-_U45-Pad2_ Net-_U46-Pad2_ 3_and
X16 Net-_U12-Pad6_ Net-_U25-Pad6_ Net-_U6-Pad2_ Net-_U47-Pad2_ 3_and
U46 Net-_U46-Pad1_ Net-_U46-Pad2_ Net-_U42-Pad1_ d_and
U44 Net-_U10-Pad1_ Net-_U44-Pad2_ Net-_U39-Pad1_ d_and
U47 Net-_U1-Pad11_ Net-_U47-Pad2_ Net-_U46-Pad1_ d_and
U58 Net-_U1-Pad11_ Net-_U55-Pad1_ d_inverter
X17 Net-_U6-Pad2_ Net-_U1-Pad11_ Net-_U49-Pad2_ Net-_U50-Pad2_ 3_and
X18 Net-_U10-Pad1_ Net-_U6-Pad2_ Net-_U18-Pad1_ Net-_U53-Pad2_ 3_and
U53 Net-_U53-Pad1_ Net-_U53-Pad2_ Net-_U52-Pad1_ d_and
U50 Net-_U18-Pad1_ Net-_U50-Pad2_ Net-_U50-Pad3_ d_and
U55 Net-_U55-Pad1_ Net-_U55-Pad2_ Net-_U53-Pad1_ d_and
X19 Net-_U12-Pad6_ Net-_U25-Pad6_ Net-_U20-Pad2_ Net-_U55-Pad2_ 3_and
U51 Net-_U51-Pad1_ Net-_U20-Pad1_ d_inverter
U52 Net-_U52-Pad1_ Net-_U50-Pad3_ Net-_U52-Pad3_ d_or
U54 Net-_U54-Pad1_ Net-_U52-Pad3_ Net-_U54-Pad3_ d_or
U60 Net-_U60-Pad1_ Net-_U56-Pad3_ Net-_U57-Pad1_ d_or
U56 Net-_U56-Pad1_ Net-_U54-Pad3_ Net-_U56-Pad3_ d_or
U30 Net-_U1-Pad11_ Net-_U30-Pad2_ Net-_U24-Pad1_ d_and
U34 Net-_U1-Pad12_ Net-_U34-Pad2_ Net-_U34-Pad3_ d_and
U32 Net-_U32-Pad1_ Net-_U32-Pad2_ Net-_U27-Pad1_ d_and
X7 Net-_U1-Pad11_ Net-_U6-Pad2_ Net-_U31-Pad2_ Net-_U32-Pad2_ 3_and
X8 Net-_U20-Pad1_ Net-_U1-Pad14_ Net-_U10-Pad1_ Net-_U32-Pad1_ 3_and
U18 Net-_U18-Pad1_ Net-_U18-Pad2_ Net-_U18-Pad3_ d_and
U21 Net-_U20-Pad3_ Net-_U21-Pad2_ d_inverter
X6 Net-_U6-Pad2_ Net-_U29-Pad2_ Net-_U1-Pad11_ Net-_U30-Pad2_ 3_and
U28 Net-_U10-Pad1_ Net-_U1-Pad14_ Net-_U28-Pad3_ d_and
U29 Net-_U28-Pad3_ Net-_U29-Pad2_ d_inverter
X4 Net-_U18-Pad1_ Net-_U21-Pad2_ Net-_U25-Pad6_ Net-_U22-Pad2_ 3_and
X5 Net-_U10-Pad1_ Net-_U12-Pad6_ Net-_U6-Pad2_ Net-_U22-Pad1_ 3_and
U22 Net-_U22-Pad1_ Net-_U22-Pad2_ Net-_U19-Pad1_ d_and
U31 Net-_U1-Pad11_ Net-_U31-Pad2_ d_inverter
X3 Net-_U1-Pad11_ Net-_U6-Pad2_ Net-_U17-Pad2_ Net-_U18-Pad2_ 3_and
U17 Net-_U16-Pad3_ Net-_U17-Pad2_ d_inverter
U16 Net-_U10-Pad1_ Net-_U12-Pad6_ Net-_U16-Pad3_ d_and
U20 Net-_U20-Pad1_ Net-_U20-Pad2_ Net-_U20-Pad3_ d_and
X9 Net-_U10-Pad1_ Net-_U1-Pad14_ Net-_U1-Pad13_ Net-_U33-Pad1_ 3_and
U27 Net-_U27-Pad1_ Net-_U24-Pad3_ Net-_U25-Pad1_ d_or
U24 Net-_U24-Pad1_ Net-_U23-Pad3_ Net-_U24-Pad3_ d_or
U25 Net-_U25-Pad1_ Net-_U1-Pad2_ unconnected-_U25-Pad3_ unconnected-_U25-Pad4_ Net-_U1-Pad13_ Net-_U25-Pad6_ d_dff
U23 Net-_U23-Pad1_ Net-_U19-Pad3_ Net-_U23-Pad3_ d_or
U19 Net-_U19-Pad1_ Net-_U18-Pad3_ Net-_U19-Pad3_ d_or
U41 Net-_U1-Pad5_ Net-_U13-Pad2_ Net-_U36-Pad1_ d_and
U59 Net-_U1-Pad6_ Net-_U13-Pad2_ Net-_U54-Pad1_ d_and
.end
