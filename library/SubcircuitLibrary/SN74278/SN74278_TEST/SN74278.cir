.title KiCad schematic
U35 Net-_U35-Pad1_ Net-_U33-Pad1_ d_inverter
U27 Net-_U27-Pad1_ Net-_U25-Pad1_ d_inverter
U5 Net-_U14-Pad2_ Net-_U18-Pad1_ Net-_U14-Pad1_ Net-_U1-Pad2_ Net-_U1-Pad3_ Net-_U15-Pad2_ unconnected-_U5-Pad7_ Net-_U24-Pad2_ Net-_U32-Pad2_ Net-_U39-Pad2_ Net-_U35-Pad1_ Net-_U27-Pad1_ unconnected-_U5-Pad14_ PORT
U33 Net-_U33-Pad1_ Net-_U14-Pad2_ Net-_U33-Pad3_ d_and
U38 Net-_U35-Pad1_ Net-_U14-Pad2_ Net-_U37-Pad1_ d_and
U31 Net-_U27-Pad1_ Net-_U14-Pad2_ Net-_U30-Pad1_ d_and
U12 Net-_U12-Pad1_ Net-_U12-Pad2_ Net-_U11-Pad1_ d_or
U17 Net-_U17-Pad1_ Net-_U16-Pad3_ Net-_U11-Pad2_ d_nor
U16 Net-_U16-Pad1_ Net-_U14-Pad2_ Net-_U16-Pad3_ d_and
U32 Net-_U28-Pad3_ Net-_U32-Pad2_ d_inverter
U28 Net-_U28-Pad1_ Net-_U1-Pad2_ Net-_U28-Pad3_ d_or
U29 Net-_U12-Pad1_ Net-_U26-Pad1_ Net-_U28-Pad1_ d_or
U37 Net-_U37-Pad1_ Net-_U12-Pad1_ Net-_U34-Pad1_ d_nor
U34 Net-_U34-Pad1_ Net-_U33-Pad3_ Net-_U12-Pad1_ d_nor
U30 Net-_U30-Pad1_ Net-_U12-Pad2_ Net-_U26-Pad1_ d_nor
U26 Net-_U26-Pad1_ Net-_U25-Pad3_ Net-_U12-Pad2_ d_nor
U22 Net-_U22-Pad1_ Net-_U11-Pad2_ Net-_U17-Pad1_ d_nor
U36 Net-_U34-Pad1_ Net-_U1-Pad2_ Net-_U36-Pad3_ d_or
U39 Net-_U36-Pad3_ Net-_U39-Pad2_ d_inverter
U25 Net-_U25-Pad1_ Net-_U14-Pad2_ Net-_U25-Pad3_ d_and
U18 Net-_U18-Pad1_ Net-_U16-Pad1_ d_inverter
U23 Net-_U18-Pad1_ Net-_U14-Pad2_ Net-_U22-Pad1_ d_and
U3 Net-_U3-Pad1_ Net-_U11-Pad2_ Net-_U2-Pad1_ d_or
U4 Net-_U12-Pad1_ Net-_U12-Pad2_ Net-_U3-Pad1_ d_or
U10 Net-_U10-Pad1_ Net-_U10-Pad2_ Net-_U10-Pad3_ d_or
U1 Net-_U1-Pad1_ Net-_U1-Pad2_ Net-_U1-Pad3_ d_or
U15 Net-_U15-Pad1_ Net-_U15-Pad2_ d_inverter
U9 Net-_U10-Pad3_ Net-_U1-Pad2_ Net-_U15-Pad1_ d_or
U2 Net-_U2-Pad1_ Net-_U13-Pad2_ Net-_U1-Pad1_ d_or
U20 Net-_U20-Pad1_ Net-_U17-Pad1_ Net-_U19-Pad1_ d_or
U19 Net-_U19-Pad1_ Net-_U1-Pad2_ Net-_U19-Pad3_ d_or
U24 Net-_U19-Pad3_ Net-_U24-Pad2_ d_inverter
U21 Net-_U12-Pad1_ Net-_U12-Pad2_ Net-_U20-Pad1_ d_or
U11 Net-_U11-Pad1_ Net-_U11-Pad2_ Net-_U10-Pad1_ d_or
U13 Net-_U13-Pad1_ Net-_U13-Pad2_ Net-_U10-Pad2_ d_nor
U7 Net-_U10-Pad2_ Net-_U6-Pad3_ Net-_U13-Pad2_ d_nor
U6 Net-_U6-Pad1_ Net-_U14-Pad2_ Net-_U6-Pad3_ d_and
U14 Net-_U14-Pad1_ Net-_U14-Pad2_ Net-_U13-Pad1_ d_and
U8 Net-_U14-Pad1_ Net-_U6-Pad1_ d_inverter
.end
