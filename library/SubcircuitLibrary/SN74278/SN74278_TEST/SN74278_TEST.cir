.title KiCad schematic
X1 Net-_U1-Pad8_ Net-_U1-Pad11_ Net-_U1-Pad12_ Net-_U1-Pad7_ Net-_U2-Pad5_ Net-_U2-Pad4_ unconnected-_X1-Pad7_ Net-_U2-Pad3_ Net-_U2-Pad2_ Net-_U2-Pad1_ Net-_U1-Pad9_ Net-_U1-Pad10_ unconnected-_X1-Pad14_ SN74278
U2 Net-_U2-Pad1_ Net-_U2-Pad2_ Net-_U2-Pad3_ Net-_U2-Pad4_ Net-_U2-Pad5_ Y1 Y2 Y3 Y4 P1 dac_bridge_5
v5 D3 GND pwl
v6 D4 GND pwl
v4 D2 GND pwl
v3 D1 GND pwl
U1 P0 G D1 D2 D3 D4 Net-_U1-Pad7_ Net-_U1-Pad8_ Net-_U1-Pad9_ Net-_U1-Pad10_ Net-_U1-Pad11_ Net-_U1-Pad12_ adc_bridge_6
v1 P0 GND pwl
v2 G GND pwl
.end
