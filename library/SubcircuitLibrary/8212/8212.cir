.title KiCad schematic
SC3 Net-_SC1-Pad1_ Net-_SC3-Pad2_ Net-_SC3-Pad3_ sky130_stdcells__nor2b_1
U24 Net-_SC2-Pad1_ Net-_SC4-Pad1_ Net-_U5-Pad1_ Net-_U6-Pad3_ Net-_U7-Pad1_ Net-_U8-Pad3_ Net-_U9-Pad1_ Net-_U10-Pad3_ Net-_U11-Pad1_ Net-_U12-Pad3_ Net-_SC4-Pad2_ Net-_SC2-Pad2_ Net-_U22-Pad1_ Net-_U14-Pad3_ Net-_U13-Pad1_ Net-_U16-Pad3_ Net-_U15-Pad1_ Net-_U18-Pad3_ Net-_U17-Pad1_ Net-_U20-Pad3_ Net-_U19-Pad1_ Net-_SC3-Pad3_ PORT
U5 Net-_U5-Pad1_ Net-_U4-Pad3_ unconnected-_U5-Pad3_ Net-_SC1-Pad2_ Net-_U5-Pad5_ unconnected-_U5-Pad6_ d_dff
U2 Net-_SC4-Pad1_ Net-_SC1-Pad1_ Net-_U2-Pad3_ d_or
U4 Net-_U3-Pad3_ Net-_SC4-Pad3_ Net-_U4-Pad3_ d_or
U1 GND Net-_SC4-Pad2_ Net-_U1-Pad3_ unconnected-_U1-Pad4_ Net-_SC3-Pad2_ unconnected-_U1-Pad6_ d_dff
SC1 Net-_SC1-Pad1_ Net-_SC1-Pad2_ Net-_SC1-Pad3_ sky130_stdcells__nor2b_1
SC4 Net-_SC4-Pad1_ Net-_SC4-Pad2_ Net-_SC4-Pad3_ sky130_stdcells__and2b_1
U3 Net-_SC1-Pad1_ Net-_SC4-Pad1_ Net-_U3-Pad3_ d_and
SC2 Net-_SC2-Pad1_ Net-_SC2-Pad2_ Net-_SC1-Pad1_ sky130_stdcells__and2b_1
U25 Net-_SC1-Pad3_ Net-_U1-Pad3_ d_inverter
U7 Net-_U7-Pad1_ Net-_U4-Pad3_ unconnected-_U7-Pad3_ Net-_SC1-Pad2_ Net-_U7-Pad5_ unconnected-_U7-Pad6_ d_dff
U9 Net-_U9-Pad1_ Net-_U4-Pad3_ unconnected-_U9-Pad3_ Net-_SC1-Pad2_ Net-_U9-Pad5_ unconnected-_U9-Pad6_ d_dff
U11 Net-_U11-Pad1_ Net-_U4-Pad3_ unconnected-_U11-Pad3_ Net-_SC1-Pad2_ Net-_U11-Pad5_ unconnected-_U11-Pad6_ d_dff
U19 Net-_U19-Pad1_ Net-_U4-Pad3_ unconnected-_U19-Pad3_ Net-_SC1-Pad2_ Net-_U19-Pad5_ unconnected-_U19-Pad6_ d_dff
U20 Net-_U19-Pad5_ Net-_U2-Pad3_ Net-_U20-Pad3_ d_tristate
U18 Net-_U17-Pad5_ Net-_U2-Pad3_ Net-_U18-Pad3_ d_tristate
U17 Net-_U17-Pad1_ Net-_U4-Pad3_ unconnected-_U17-Pad3_ Net-_SC1-Pad2_ Net-_U17-Pad5_ unconnected-_U17-Pad6_ d_dff
U23 Net-_U21-Pad2_ Net-_U22-Pad2_ Net-_SC1-Pad2_ d_nand
U21 Net-_U4-Pad3_ Net-_U21-Pad2_ d_inverter
U22 Net-_U22-Pad1_ Net-_U22-Pad2_ d_inverter
U6 Net-_U5-Pad5_ Net-_U2-Pad3_ Net-_U6-Pad3_ d_tristate
U8 Net-_U7-Pad5_ Net-_U2-Pad3_ Net-_U8-Pad3_ d_tristate
U12 Net-_U11-Pad5_ Net-_U2-Pad3_ Net-_U12-Pad3_ d_tristate
U10 Net-_U9-Pad5_ Net-_U2-Pad3_ Net-_U10-Pad3_ d_tristate
U16 Net-_U15-Pad5_ Net-_U2-Pad3_ Net-_U16-Pad3_ d_tristate
U14 Net-_U13-Pad5_ Net-_U2-Pad3_ Net-_U14-Pad3_ d_tristate
U15 Net-_U15-Pad1_ Net-_U4-Pad3_ unconnected-_U15-Pad3_ Net-_SC1-Pad2_ Net-_U15-Pad5_ unconnected-_U15-Pad6_ d_dff
U13 Net-_U13-Pad1_ Net-_U4-Pad3_ unconnected-_U13-Pad3_ Net-_SC1-Pad2_ Net-_U13-Pad5_ unconnected-_U13-Pad6_ d_dff
.end
