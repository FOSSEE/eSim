.title KiCad schematic
U9 Net-_U1-Pad6_ Net-_U5-Pad1_ d_inverter
U8 Net-_U1-Pad5_ Net-_U4-Pad1_ d_inverter
U5 Net-_U5-Pad1_ Net-_U1-Pad5_ unconnected-_U5-Pad3_ Net-_U1-Pad2_ Net-_U1-Pad6_ unconnected-_U5-Pad6_ d_dff
U4 Net-_U4-Pad1_ Net-_U1-Pad4_ unconnected-_U4-Pad3_ Net-_U1-Pad2_ Net-_U1-Pad5_ unconnected-_U4-Pad6_ d_dff
U1 Net-_U1-Pad1_ Net-_U1-Pad2_ Net-_U1-Pad3_ Net-_U1-Pad4_ Net-_U1-Pad5_ Net-_U1-Pad6_ PORT
U3 Net-_U3-Pad1_ Net-_U1-Pad3_ unconnected-_U3-Pad3_ Net-_U1-Pad2_ Net-_U1-Pad4_ unconnected-_U3-Pad6_ d_dff
U7 Net-_U1-Pad4_ Net-_U3-Pad1_ d_inverter
U6 Net-_U1-Pad3_ Net-_U2-Pad1_ d_inverter
U2 Net-_U2-Pad1_ Net-_U1-Pad1_ unconnected-_U2-Pad3_ Net-_U1-Pad2_ Net-_U1-Pad3_ unconnected-_U2-Pad6_ d_dff
.end
