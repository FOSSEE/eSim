.title KiCad schematic
U55 Net-_U25-Pad2_ Net-_U31-Pad3_ Net-_U55-Pad3_ d_nor
U59 Net-_U55-Pad3_ Net-_U55-Pad3_ Net-_U59-Pad3_ d_nor
U58 Net-_U54-Pad3_ Net-_U47-Pad3_ Net-_U58-Pad3_ d_nor
U62 Net-_U58-Pad3_ Net-_U1-Pad12_ d_inverter
U1 Net-_U1-Pad1_ Net-_U1-Pad2_ Net-_U1-Pad3_ Net-_U1-Pad4_ Net-_U1-Pad5_ Net-_U1-Pad6_ Net-_U1-Pad7_ Net-_U1-Pad9_ Net-_U1-Pad10_ Net-_U1-Pad11_ Net-_U1-Pad12_ Net-_U1-Pad13_ Net-_U1-Pad14_ Net-_U1-Pad15_ PORT
U63 Net-_U59-Pad3_ Net-_U60-Pad3_ Net-_U63-Pad3_ d_nor
U51 Net-_U49-Pad3_ Net-_U49-Pad3_ Net-_U51-Pad3_ d_nor
U49 Net-_U25-Pad2_ Net-_U31-Pad3_ Net-_U49-Pad3_ d_nor
U50 Net-_U41-Pad3_ Net-_U42-Pad3_ Net-_U50-Pad3_ d_nor
U54 Net-_U53-Pad3_ Net-_U53-Pad3_ Net-_U54-Pad3_ d_nor
U53 Net-_U51-Pad3_ Net-_U52-Pad3_ Net-_U53-Pad3_ d_nor
U57 Net-_U47-Pad3_ Net-_U1-Pad3_ Net-_U57-Pad3_ d_nor
U56 Net-_U41-Pad3_ Net-_U42-Pad3_ Net-_U56-Pad3_ d_nor
U60 Net-_U56-Pad3_ Net-_U56-Pad3_ Net-_U60-Pad3_ d_nor
U66 Net-_U65-Pad3_ Net-_U65-Pad3_ Net-_U66-Pad3_ d_nor
U67 Net-_U66-Pad3_ Net-_U2-Pad2_ Net-_U1-Pad13_ d_nor
U64 Net-_U63-Pad3_ Net-_U63-Pad3_ Net-_U64-Pad3_ d_nor
U61 Net-_U57-Pad3_ Net-_U57-Pad3_ Net-_U61-Pad3_ d_nor
U65 Net-_U64-Pad3_ Net-_U61-Pad3_ Net-_U65-Pad3_ d_nor
U52 Net-_U50-Pad3_ Net-_U50-Pad3_ Net-_U52-Pad3_ d_nor
U47 Net-_U45-Pad3_ Net-_U21-Pad3_ Net-_U47-Pad3_ d_nor
U48 Net-_U46-Pad3_ Net-_U21-Pad3_ Net-_U1-Pad3_ d_nor
U23 Net-_U17-Pad3_ Net-_U18-Pad3_ Net-_U23-Pad3_ d_nand
U24 Net-_U20-Pad3_ Net-_U19-Pad3_ Net-_U24-Pad3_ d_nand
U8 Net-_U1-Pad14_ Net-_U14-Pad2_ d_inverter
U9 Net-_U1-Pad2_ Net-_U15-Pad1_ d_inverter
U7 Net-_U1-Pad15_ Net-_U13-Pad1_ d_inverter
U10 Net-_U1-Pad7_ Net-_U10-Pad2_ d_inverter
U11 Net-_U1-Pad9_ Net-_U11-Pad2_ d_inverter
U12 Net-_U1-Pad1_ Net-_U12-Pad2_ d_inverter
U5 Net-_U1-Pad10_ Net-_U20-Pad1_ d_inverter
U6 Net-_U1-Pad11_ Net-_U19-Pad2_ d_inverter
U3 Net-_U1-Pad5_ Net-_U29-Pad1_ d_inverter
U18 Net-_U1-Pad7_ Net-_U11-Pad2_ Net-_U18-Pad3_ d_nand
U20 Net-_U20-Pad1_ Net-_U1-Pad11_ Net-_U20-Pad3_ d_nand
U19 Net-_U1-Pad10_ Net-_U19-Pad2_ Net-_U19-Pad3_ d_nand
U2 Net-_U1-Pad4_ Net-_U2-Pad2_ d_inverter
U4 Net-_U1-Pad6_ Net-_U30-Pad1_ d_inverter
U22 Net-_U15-Pad3_ Net-_U16-Pad3_ Net-_U22-Pad3_ d_nand
U14 Net-_U1-Pad15_ Net-_U14-Pad2_ Net-_U14-Pad3_ d_nand
U16 Net-_U1-Pad2_ Net-_U12-Pad2_ Net-_U16-Pad3_ d_nand
U17 Net-_U10-Pad2_ Net-_U1-Pad9_ Net-_U17-Pad3_ d_nand
U15 Net-_U15-Pad1_ Net-_U1-Pad1_ Net-_U15-Pad3_ d_nand
U13 Net-_U13-Pad1_ Net-_U1-Pad14_ Net-_U13-Pad3_ d_nand
U21 Net-_U13-Pad3_ Net-_U14-Pad3_ Net-_U21-Pad3_ d_nand
U29 Net-_U29-Pad1_ Net-_U24-Pad3_ Net-_U29-Pad3_ d_nor
U32 Net-_U23-Pad3_ Net-_U22-Pad3_ Net-_U32-Pad3_ d_nor
U28 Net-_U20-Pad3_ Net-_U23-Pad3_ Net-_U28-Pad3_ d_nor
U25 Net-_U13-Pad3_ Net-_U25-Pad2_ d_inverter
U31 Net-_U21-Pad3_ Net-_U15-Pad3_ Net-_U31-Pad3_ d_nor
U36 Net-_U28-Pad3_ Net-_U28-Pad3_ Net-_U36-Pad3_ d_nor
U35 Net-_U27-Pad3_ Net-_U27-Pad3_ Net-_U35-Pad3_ d_nor
U27 Net-_U22-Pad3_ Net-_U21-Pad3_ Net-_U27-Pad3_ d_nor
U34 Net-_U26-Pad3_ Net-_U26-Pad3_ Net-_U34-Pad3_ d_nor
U26 Net-_U22-Pad3_ Net-_U17-Pad3_ Net-_U26-Pad3_ d_nor
U42 Net-_U35-Pad3_ Net-_U36-Pad3_ Net-_U42-Pad3_ d_nor
U41 Net-_U34-Pad3_ Net-_U21-Pad3_ Net-_U41-Pad3_ d_nor
U46 Net-_U44-Pad3_ Net-_U44-Pad3_ Net-_U46-Pad3_ d_nor
U44 Net-_U39-Pad3_ Net-_U40-Pad3_ Net-_U44-Pad3_ d_nor
U39 Net-_U30-Pad3_ Net-_U30-Pad3_ Net-_U39-Pad3_ d_nor
U33 Net-_U23-Pad3_ Net-_U22-Pad3_ Net-_U33-Pad3_ d_nor
U38 Net-_U32-Pad3_ Net-_U32-Pad3_ Net-_U38-Pad3_ d_nor
U40 Net-_U33-Pad3_ Net-_U33-Pad3_ Net-_U40-Pad3_ d_nor
U30 Net-_U30-Pad1_ Net-_U24-Pad3_ Net-_U30-Pad3_ d_nor
U37 Net-_U29-Pad3_ Net-_U29-Pad3_ Net-_U37-Pad3_ d_nor
U45 Net-_U43-Pad3_ Net-_U43-Pad3_ Net-_U45-Pad3_ d_nor
U43 Net-_U37-Pad3_ Net-_U38-Pad3_ Net-_U43-Pad3_ d_nor
.end
