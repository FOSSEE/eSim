.title KiCad schematic
U5 Net-_U4-Pad3_ Net-_U5-Pad2_ d_inverter
SC1 Net-_U4-Pad3_ Net-_SC1-Pad2_ Net-_U3-Pad2_ Net-_U6-Pad2_ sky130_stdcells__nand3_1
U3 Net-_U1-Pad1_ Net-_U3-Pad2_ d_buffer
U4 Net-_U1-Pad2_ Net-_U2-Pad2_ Net-_U4-Pad3_ d_or
U14 Net-_U2-Pad1_ Net-_U11-Pad6_ Net-_SC3-Pad2_ Net-_SC1-Pad2_ Net-_U7-Pad6_ Net-_U9-Pad3_ Net-_U7-Pad3_ Net-_U9-Pad6_ Net-_SC2-Pad2_ Net-_SC4-Pad2_ Net-_U13-Pad6_ Net-_U1-Pad1_ PORT
U2 Net-_U2-Pad1_ Net-_U2-Pad2_ d_inverter
U1 Net-_U1-Pad1_ Net-_U1-Pad2_ d_inverter
U8 Net-_U4-Pad3_ Net-_U8-Pad2_ Net-_U8-Pad3_ d_nand
SC2 Net-_U4-Pad3_ Net-_SC2-Pad2_ Net-_U3-Pad2_ Net-_U8-Pad2_ sky130_stdcells__nand3_1
SC3 Net-_U4-Pad3_ Net-_SC3-Pad2_ Net-_U3-Pad2_ Net-_U10-Pad2_ sky130_stdcells__nand3_1
U9 Net-_U5-Pad2_ Net-_U5-Pad2_ Net-_U9-Pad3_ Net-_U8-Pad2_ Net-_U8-Pad3_ Net-_U9-Pad6_ unconnected-_U9-Pad7_ d_jkff
U11 Net-_U5-Pad2_ Net-_U5-Pad2_ Net-_U9-Pad6_ Net-_U10-Pad2_ Net-_U10-Pad3_ Net-_U11-Pad6_ unconnected-_U11-Pad7_ d_jkff
U10 Net-_U4-Pad3_ Net-_U10-Pad2_ Net-_U10-Pad3_ d_nand
U12 Net-_U4-Pad3_ Net-_U12-Pad2_ Net-_U12-Pad3_ d_nand
SC4 Net-_U4-Pad3_ Net-_SC4-Pad2_ Net-_U3-Pad2_ Net-_U12-Pad2_ sky130_stdcells__nand3_1
U13 Net-_U5-Pad2_ Net-_U5-Pad2_ Net-_U11-Pad6_ Net-_U12-Pad2_ Net-_U12-Pad3_ Net-_U13-Pad6_ unconnected-_U13-Pad7_ d_jkff
U6 Net-_U4-Pad3_ Net-_U6-Pad2_ Net-_U6-Pad3_ d_nand
U7 Net-_U5-Pad2_ Net-_U5-Pad2_ Net-_U7-Pad3_ Net-_U6-Pad2_ Net-_U6-Pad3_ Net-_U7-Pad6_ unconnected-_U7-Pad7_ d_jkff
.end
