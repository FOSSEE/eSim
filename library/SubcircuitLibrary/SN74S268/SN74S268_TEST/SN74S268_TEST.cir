.title KiCad schematic
v1 IN GND pulse
v2 OUT_CTRL GND pwl
U1 IN IN IN IN IN IN Net-_U1-Pad7_ Net-_U1-Pad8_ Net-_U1-Pad9_ Net-_U1-Pad10_ Net-_U1-Pad11_ Net-_U1-Pad12_ adc_bridge_6
v3 EN GND pwl
X1 Net-_U2-Pad3_ Net-_U3-Pad1_ Net-_U1-Pad7_ Net-_U1-Pad8_ Net-_U3-Pad2_ Net-_U1-Pad9_ Net-_U3-Pad3_ Net-_U2-Pad4_ Net-_U3-Pad4_ Net-_U1-Pad10_ Net-_U3-Pad5_ Net-_U1-Pad11_ Net-_U1-Pad12_ Net-_U3-Pad6_ SN74S268
U3 Net-_U3-Pad1_ Net-_U3-Pad2_ Net-_U3-Pad3_ Net-_U3-Pad4_ Net-_U3-Pad5_ Net-_U3-Pad6_ Q1 Q2 Q3 Q4 Q5 Q6 dac_bridge_6
U2 OUT_CTRL EN Net-_U2-Pad3_ Net-_U2-Pad4_ adc_bridge_2
.end
