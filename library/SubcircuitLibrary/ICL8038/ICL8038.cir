.title KiCad schematic
Q41 GND Net-_Q41-Pad2_ Net-_Q41-Pad3_ eSim_PNP
R22 Net-_Q34-Pad2_ Net-_Q2-Pad1_ 5K
R27 Net-_Q45-Pad3_ Net-_Q49-Pad3_ 800
R25 Net-_Q41-Pad3_ Net-_Q49-Pad3_ 2.7K
R35 GND Net-_Q45-Pad2_ 33K
Q43 Net-_Q2-Pad1_ Net-_Q43-Pad2_ Net-_Q41-Pad2_ eSim_NPN
R31 GND Net-_Q41-Pad2_ 33K
R37 GND Net-_Q50-Pad2_ 33K
R41 Net-_Q39-Pad2_ Net-_Q43-Pad2_ 330
R42 Net-_Q40-Pad2_ Net-_Q39-Pad2_ 1600
Q42 Net-_Q2-Pad1_ Net-_Q42-Pad2_ Net-_Q42-Pad3_ eSim_NPN
R29 Net-_Q37-Pad2_ Net-_Q2-Pad1_ 33K
Q40 GND Net-_Q40-Pad2_ Net-_Q37-Pad2_ eSim_PNP
R30 Net-_Q42-Pad3_ Net-_Q49-Pad3_ 2.7K
Q39 Net-_Q2-Pad1_ Net-_Q39-Pad2_ Net-_Q38-Pad2_ eSim_NPN
R28 GND Net-_Q38-Pad2_ 33K
Q30 GND Net-_Q30-Pad2_ Net-_Q26-Pad3_ eSim_PNP
Q32 Net-_Q2-Pad1_ Net-_Q32-Pad2_ Net-_Q28-Pad3_ eSim_NPN
R44 Net-_Q47-Pad2_ Net-_Q44-Pad2_ 375
R43 Net-_Q44-Pad2_ Net-_Q40-Pad2_ 330
Q47 GND Net-_Q47-Pad2_ Net-_Q46-Pad2_ eSim_PNP
R33 Net-_Q46-Pad3_ Net-_Q49-Pad3_ 800
Q46 Net-_Q2-Pad1_ Net-_Q46-Pad2_ Net-_Q46-Pad3_ eSim_NPN
Q44 GND Net-_Q44-Pad2_ Net-_Q42-Pad2_ eSim_PNP
R32 Net-_Q42-Pad2_ Net-_Q2-Pad1_ 33K
R34 Net-_Q46-Pad2_ Net-_Q2-Pad1_ 33K
R36 Net-_Q49-Pad2_ Net-_Q2-Pad1_ 33K
Q50 GND Net-_Q50-Pad2_ Net-_Q49-Pad3_ eSim_PNP
Q52 Net-_Q2-Pad1_ Net-_Q52-Pad2_ Net-_Q50-Pad2_ eSim_NPN
R40 Net-_Q43-Pad2_ Net-_Q48-Pad2_ 375
U1 Net-_Q52-Pad2_ Net-_Q49-Pad3_ Net-_Q35-Pad3_ Net-_Q15-Pad3_ Net-_Q10-Pad1_ Net-_Q2-Pad1_ Net-_R2-Pad1_ Net-_Q4-Pad3_ Net-_Q1-Pad1_ Net-_Q18-Pad3_ GND Net-_Q51-Pad2_ unconnected-_U1-Pad13_ unconnected-_U1-Pad14_ PORT
R38 Net-_Q52-Pad2_ Net-_Q2-Pad1_ 5.2K
Q48 Net-_Q2-Pad1_ Net-_Q48-Pad2_ Net-_Q45-Pad2_ eSim_NPN
Q45 GND Net-_Q45-Pad2_ Net-_Q45-Pad3_ eSim_PNP
R39 Net-_Q48-Pad2_ Net-_Q52-Pad2_ 200
R45 Net-_Q51-Pad2_ Net-_Q47-Pad2_ 200
Q51 GND Net-_Q51-Pad2_ Net-_Q49-Pad2_ eSim_PNP
Q49 Net-_Q2-Pad1_ Net-_Q49-Pad2_ Net-_Q49-Pad3_ eSim_NPN
R46 GND Net-_Q51-Pad2_ 5.6K
R26 Net-_Q37-Pad3_ Net-_Q49-Pad3_ 10K
Q37 Net-_Q2-Pad1_ Net-_Q37-Pad2_ Net-_Q37-Pad3_ eSim_NPN
Q33 GND Net-_Q33-Pad2_ Net-_Q30-Pad2_ eSim_PNP
R21 GND Net-_Q33-Pad2_ 5K
R24 Net-_Q38-Pad3_ Net-_Q49-Pad3_ 10K
Q38 GND Net-_Q38-Pad2_ Net-_Q38-Pad3_ eSim_PNP
R20 Net-_Q33-Pad2_ Net-_Q34-Pad2_ 5K
Q34 Net-_Q2-Pad1_ Net-_Q34-Pad2_ Net-_Q32-Pad2_ eSim_NPN
R7A1 GND Net-_Q28-Pad3_ 10K
R23 Net-_Q49-Pad3_ Net-_Q35-Pad3_ 1K
Q31 Net-_Q31-Pad1_ Net-_Q31-Pad1_ Net-_Q29-Pad3_ eSim_NPN
R19 Net-_Q31-Pad1_ Net-_Q2-Pad1_ 27K
Q29 GND Net-_Q27-Pad3_ Net-_Q29-Pad3_ eSim_PNP
R18 GND Net-_Q27-Pad3_ 27K
Q35 Net-_Q2-Pad1_ Net-_Q31-Pad1_ Net-_Q35-Pad3_ eSim_NPN
Q36 GND Net-_Q27-Pad3_ Net-_Q35-Pad3_ eSim_PNP
Q21 Net-_Q12-Pad2_ Net-_Q12-Pad2_ Net-_Q21-Pad3_ eSim_NPN
Q19 Net-_Q18-Pad3_ Net-_Q11-Pad3_ Net-_Q12-Pad2_ eSim_NPN
Q18 Net-_Q17-Pad3_ Net-_Q17-Pad3_ Net-_Q18-Pad3_ eSim_NPN
Q17 Net-_Q15-Pad3_ Net-_Q15-Pad1_ Net-_Q17-Pad3_ eSim_NPN
R14 Net-_Q15-Pad3_ Net-_Q2-Pad1_ 10K
R9 Net-_Q10-Pad1_ Net-_Q2-Pad1_ 10K
R41A1 Net-_Q22-Pad2_ Net-_Q2-Pad1_ 4K
Q22 Net-_Q20-Pad1_ Net-_Q22-Pad2_ Net-_Q2-Pad1_ eSim_PNP
Q27 Net-_Q2-Pad1_ Net-_Q23-Pad3_ Net-_Q27-Pad3_ eSim_NPN
Q23 Net-_Q2-Pad1_ Net-_Q17-Pad3_ Net-_Q23-Pad3_ eSim_NPN
R17 GND Net-_Q20-Pad1_ 4.7K
R41B1 Net-_Q27-Pad3_ Net-_Q23-Pad3_ 27K
Q26 Net-_Q13-Pad1_ Net-_Q24-Pad3_ Net-_Q26-Pad3_ eSim_PNP
Q24 Net-_Q13-Pad1_ Net-_Q18-Pad3_ Net-_Q24-Pad3_ eSim_PNP
Q7 Net-_Q7-Pad1_ Net-_Q11-Pad3_ GND schottky_transistor
R8 Net-_Q7-Pad1_ Net-_Q14-Pad2_ 470
Q20 Net-_Q20-Pad1_ Net-_Q14-Pad2_ GND schottky_transistor
Q14 Net-_Q13-Pad2_ Net-_Q14-Pad2_ GND schottky_transistor
Q13 Net-_Q13-Pad1_ Net-_Q13-Pad2_ GND schottky_transistor
Q9 Net-_Q14-Pad2_ Net-_Q3-Pad2_ GND schottky_transistor
R11 Net-_Q13-Pad2_ Net-_Q3-Pad2_ 27K
R16 GND Net-_Q13-Pad1_ 4.7K
Q28 Net-_Q22-Pad2_ Net-_Q25-Pad3_ Net-_Q28-Pad3_ eSim_NPN
R7B1 Net-_Q26-Pad3_ Net-_Q2-Pad1_ 15K
Q25 Net-_Q22-Pad2_ Net-_Q18-Pad3_ Net-_Q25-Pad3_ eSim_NPN
R10 GND Net-_Q12-Pad3_ 100
R15 GND Net-_Q21-Pad3_ 100
R12 Net-_Q14-Pad2_ Net-_Q2-Pad3_ 1.8K
R13 GND Net-_Q16-Pad3_ 100
Q15 Net-_Q15-Pad1_ Net-_Q15-Pad2_ Net-_Q15-Pad3_ eSim_PNP
Q11 Net-_Q10-Pad3_ Net-_Q11-Pad2_ Net-_Q11-Pad3_ eSim_NPN
Q12 Net-_Q11-Pad3_ Net-_Q12-Pad2_ Net-_Q12-Pad3_ eSim_NPN
R6 Net-_Q11-Pad3_ Net-_Q6-Pad3_ 40K
Q6 Net-_Q15-Pad2_ Net-_Q11-Pad2_ Net-_Q6-Pad3_ eSim_NPN
Q10 Net-_Q10-Pad1_ Net-_Q10-Pad2_ Net-_Q10-Pad3_ eSim_NPN
Q8 Net-_Q10-Pad2_ Net-_Q15-Pad2_ Net-_Q10-Pad1_ eSim_PNP
Q16 Net-_Q12-Pad2_ Net-_Q12-Pad2_ Net-_Q16-Pad3_ eSim_NPN
R3 GND Net-_R2-Pad1_ 39K
R2 Net-_R2-Pad1_ Net-_Q2-Pad1_ 11K
Q4 Net-_Q15-Pad2_ Net-_Q15-Pad2_ Net-_Q4-Pad3_ eSim_PNP
Q2 Net-_Q2-Pad1_ Net-_D1-Pad1_ Net-_Q2-Pad3_ eSim_NPN
D1 Net-_D1-Pad1_ Net-_D1-Pad2_ eSim_Diode
Q5 Net-_Q2-Pad1_ Net-_Q4-Pad3_ Net-_Q15-Pad2_ eSim_NPN
R1 Net-_D1-Pad1_ Net-_Q2-Pad1_ 30K
R7 Net-_Q3-Pad2_ Net-_Q2-Pad3_ 620
R5 GND Net-_Q1-Pad2_ 2.7K
Q1 Net-_Q1-Pad1_ Net-_Q1-Pad2_ GND eSim_NPN
R4 Net-_Q1-Pad2_ Net-_Q3-Pad3_ 270
D4 Net-_D3-Pad2_ GND eSim_Diode
Q3 Net-_Q2-Pad1_ Net-_Q3-Pad2_ Net-_Q3-Pad3_ eSim_NPN
D2 Net-_D1-Pad2_ Net-_D2-Pad2_ eSim_Diode
D3 Net-_D2-Pad2_ Net-_D3-Pad2_ eSim_Diode
.end
