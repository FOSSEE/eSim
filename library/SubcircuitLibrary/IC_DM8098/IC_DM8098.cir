.title KiCad schematic
U9 Net-_U1-Pad4_ Net-_U4-Pad2_ Net-_U15-Pad1_ d_tristate
U10 Net-_U1-Pad5_ Net-_U10-Pad2_ Net-_U10-Pad3_ d_tristate
U11 Net-_U1-Pad6_ Net-_U10-Pad2_ Net-_U11-Pad3_ d_tristate
U3 Net-_U1-Pad8_ Net-_U3-Pad2_ d_inverter
U1 Net-_U1-Pad1_ Net-_U1-Pad2_ Net-_U1-Pad3_ Net-_U1-Pad4_ Net-_U1-Pad5_ Net-_U1-Pad6_ Net-_U1-Pad7_ Net-_U1-Pad8_ Net-_U17-Pad2_ Net-_U16-Pad2_ Net-_U15-Pad2_ Net-_U14-Pad2_ Net-_U13-Pad2_ Net-_U12-Pad2_ PORT
U2 Net-_U1-Pad7_ Net-_U2-Pad2_ d_inverter
U15 Net-_U15-Pad1_ Net-_U15-Pad2_ d_inverter
U17 Net-_U11-Pad3_ Net-_U17-Pad2_ d_inverter
U16 Net-_U10-Pad3_ Net-_U16-Pad2_ d_inverter
U4 Net-_U2-Pad2_ Net-_U4-Pad2_ d_buffer
U5 Net-_U3-Pad2_ Net-_U10-Pad2_ d_buffer
U8 Net-_U1-Pad3_ Net-_U4-Pad2_ Net-_U14-Pad1_ d_tristate
U13 Net-_U13-Pad1_ Net-_U13-Pad2_ d_inverter
U12 Net-_U12-Pad1_ Net-_U12-Pad2_ d_inverter
U6 Net-_U1-Pad1_ Net-_U4-Pad2_ Net-_U12-Pad1_ d_tristate
U7 Net-_U1-Pad2_ Net-_U4-Pad2_ Net-_U13-Pad1_ d_tristate
U14 Net-_U14-Pad1_ Net-_U14-Pad2_ d_inverter
.end
