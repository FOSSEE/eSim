.title KiCad schematic
U7 Net-_U16-Pad1_ Qa_bar set_dig reset_dig Qb Qb_bar d_tff
U6 Net-_U16-Pad1_ clk_dig set_dig reset_dig Qa Qa_bar d_tff
U2 GND Net-_U2-Pad2_ adc_bridge_1
U5 Net-_U2-Pad2_ Net-_U16-Pad1_ d_inverter
U16 Net-_U16-Pad1_ Qc_bar set_dig reset_dig Qd Qd_bar d_tff
U8 Net-_U16-Pad1_ Qb_bar set_dig reset_dig Qc Qc_bar d_tff
U12 Cdig Qb_bar Net-_U12-Pad3_ d_and
U14 Net-_U14-Pad1_ Qc Net-_U14-Pad3_ d_and
U21 Qb Net-_U15-Pad3_ I_dig d_and
U10 Qd Qa Net-_U10-Pad3_ d_and
U13 Ddig Qa_bar Net-_U13-Pad3_ d_and
U18 Net-_U12-Pad3_ Qa Net-_U18-Pad3_ d_and
U9 Bdig Qa Net-_U14-Pad1_ d_and
U1 I_dig Cdig Ddig set_dig out_bar_dig out_dig inhibit_out_dig unconnected-_U1-Pad8_ clk_dig strobe_dig inhibit_in_dig cascade_dig reset_dig Adig Bdig unconnected-_U1-Pad16_ PORT
U38 Net-_U34-Pad2_ Net-_U35-Pad3_ Net-_U38-Pad3_ d_and
U34 strobe_dig Net-_U34-Pad2_ d_inverter
U33 cascade_dig Net-_U33-Pad2_ out_dig d_or
U41 Net-_U38-Pad3_ Net-_U39-Pad2_ Net-_U33-Pad2_ d_and
U39 inhibit_in_dig Net-_U39-Pad2_ d_inverter
U35 Net-_U28-Pad2_ Net-_U27-Pad3_ Net-_U35-Pad3_ d_and
U30 out_dig out dac_bridge_1
U32 I_dig 15_out dac_bridge_1
U31 out_bar_dig out_bar dac_bridge_1
U43 inhibit_out_dig inhibit_out dac_bridge_1
U17 Net-_U11-Pad3_ Qc Net-_U17-Pad3_ d_and
U20 Qb Net-_U14-Pad3_ Net-_U20-Pad3_ d_and
U25 Net-_U20-Pad3_ Net-_U23-Pad3_ Net-_U25-Pad3_ d_or
U24 Net-_U22-Pad3_ Qa Net-_U24-Pad3_ d_and
U28 clk_dig Net-_U28-Pad2_ d_inverter
U27 Net-_U24-Pad3_ Net-_U25-Pad3_ Net-_U27-Pad3_ d_or
U26 Qb_bar Qc_bar Net-_U26-Pad3_ d_and
U23 Net-_U18-Pad3_ Net-_U13-Pad3_ Net-_U23-Pad3_ d_or
U40 Net-_U36-Pad3_ Net-_U37-Pad2_ inhibit_out_dig d_or
U42 Net-_U33-Pad2_ out_bar_dig d_inverter
U36 inhibit_in_dig Qa_bar Net-_U36-Pad3_ d_or
U37 Net-_U29-Pad3_ Net-_U37-Pad2_ d_inverter
U11 Adig Qd_bar Net-_U11-Pad3_ d_and
U29 Net-_U26-Pad3_ Qd_bar Net-_U29-Pad3_ d_and
U15 Net-_U10-Pad3_ Qc Net-_U15-Pad3_ d_and
U22 Qb Net-_U17-Pad3_ Net-_U22-Pad3_ d_and
.end
