.title KiCad schematic
U76 Net-_U72-Pad2_ Net-_U64-Pad3_ Net-_U76-Pad3_ d_xor
U77 Net-_U66-Pad3_ /CN Net-_U77-Pad3_ d_and
U75 Net-_U71-Pad2_ Net-_U63-Pad3_ Net-_U75-Pad3_ d_xor
U84 Net-_U76-Pad3_ Net-_U2-Pad17_ d_inverter
U83 Net-_U75-Pad3_ Net-_U2-Pad16_ d_inverter
U88 Net-_U77-Pad3_ Net-_U78-Pad3_ Net-_U2-Pad15_ d_or
U2 /A0 /A1 /A2 /A3 /B0 /B1 /B2 /B3 /CN /M /S0 /S1 /S2 /S3 Net-_U2-Pad15_ Net-_U2-Pad16_ Net-_U2-Pad17_ Net-_U2-Pad18_ Net-_U2-Pad19_ Net-_U2-Pad20_ Net-_U2-Pad21_ PORT
U71 Net-_U38-Pad3_ Net-_U71-Pad2_ d_buffer
U72 Net-_U23-Pad3_ Net-_U72-Pad2_ d_buffer
U62 Net-_U55-Pad3_ Net-_U29-Pad3_ Net-_U62-Pad3_ d_and
U60 Net-_U38-Pad3_ Net-_U23-Pad3_ Net-_U60-Pad3_ d_or
U61 Net-_U55-Pad3_ Net-_U23-Pad3_ Net-_U61-Pad3_ d_and
U70 Net-_U60-Pad3_ Net-_U25-Pad3_ Net-_U70-Pad3_ d_or
U74 Net-_U42-Pad3_ Net-_U74-Pad2_ d_buffer
U67 Net-_U59-Pad3_ /M Net-_U67-Pad3_ d_xor
U68 Net-_U61-Pad3_ Net-_U36-Pad3_ Net-_U68-Pad3_ d_and
U69 Net-_U56-Pad3_ Net-_U62-Pad3_ Net-_U69-Pad3_ d_or
U66 Net-_U61-Pad3_ Net-_U38-Pad3_ Net-_U66-Pad3_ d_and
U73 Net-_U25-Pad3_ Net-_U73-Pad2_ d_buffer
U80 Net-_U73-Pad2_ Net-_U65-Pad3_ Net-_U80-Pad3_ d_xor
U81 Net-_U74-Pad2_ Net-_U67-Pad3_ Net-_U81-Pad3_ d_xor
U82 Net-_U79-Pad3_ Net-_U2-Pad21_ d_inverter
U79 Net-_U70-Pad3_ Net-_U42-Pad3_ Net-_U79-Pad3_ d_or
U78 Net-_U69-Pad3_ Net-_U68-Pad3_ Net-_U78-Pad3_ d_or
U85 Net-_U80-Pad3_ Net-_U2-Pad18_ d_inverter
U86 Net-_U81-Pad3_ Net-_U2-Pad19_ d_inverter
U87 Net-_U78-Pad3_ Net-_U2-Pad20_ d_inverter
U59 Net-_U48-Pad3_ Net-_U53-Pad3_ Net-_U59-Pad3_ d_or
U65 Net-_U58-Pad3_ /M Net-_U65-Pad3_ d_xor
U57 Net-_U36-Pad3_ Net-_U51-Pad3_ Net-_U57-Pad3_ d_or
U58 Net-_U54-Pad3_ Net-_U52-Pad3_ Net-_U58-Pad3_ d_or
U64 Net-_U57-Pad3_ /M Net-_U64-Pad3_ d_xor
U63 /CN /M Net-_U63-Pad3_ d_xor
U6 /S2 Net-_U1-Pad2_ Net-_U20-Pad2_ d_and
U10 /B0 Net-_U10-Pad2_ d_buffer
U1 /B1 Net-_U1-Pad2_ d_buffer
U27 /A0 Net-_U17-Pad3_ Net-_U27-Pad3_ d_or
U26 /S0 Net-_U21-Pad2_ Net-_U26-Pad3_ d_and
U25 Net-_U16-Pad3_ Net-_U14-Pad3_ Net-_U25-Pad3_ d_or
U24 /S1 /B3 Net-_U24-Pad3_ d_and
U21 /B0 Net-_U21-Pad2_ d_buffer
U22 Net-_U12-Pad3_ Net-_U13-Pad3_ Net-_U22-Pad3_ d_or
U23 Net-_U15-Pad3_ Net-_U11-Pad3_ Net-_U23-Pad3_ d_or
U30 /B3 Net-_U30-Pad2_ d_buffer
U31 /B3 Net-_U31-Pad2_ d_buffer
U4 /S3 /B1 Net-_U20-Pad1_ d_and
U5 /S1 /B2 Net-_U16-Pad2_ d_and
U3 /S1 /B1 Net-_U15-Pad2_ d_and
U13 /S2 Net-_U13-Pad2_ Net-_U13-Pad3_ d_and
U12 /S3 /B2 Net-_U12-Pad3_ d_and
U11 /S0 Net-_U11-Pad2_ Net-_U11-Pad3_ d_and
U9 /B2 Net-_U14-Pad2_ d_buffer
U14 /S0 Net-_U14-Pad2_ Net-_U14-Pad3_ d_and
U17 /S1 /B0 Net-_U17-Pad3_ d_and
U16 /A2 Net-_U16-Pad2_ Net-_U16-Pad3_ d_or
U15 /A1 Net-_U15-Pad2_ Net-_U15-Pad3_ d_or
U7 /B1 Net-_U11-Pad2_ d_buffer
U8 /B2 Net-_U13-Pad2_ d_buffer
U28 Net-_U18-Pad3_ Net-_U19-Pad3_ Net-_U28-Pad3_ d_or
U29 /A1 Net-_U20-Pad3_ Net-_U29-Pad3_ d_and
U18 /S3 /B0 Net-_U18-Pad3_ d_and
U19 /S2 Net-_U10-Pad2_ Net-_U19-Pad3_ d_and
U20 Net-_U20-Pad1_ Net-_U20-Pad2_ Net-_U20-Pad3_ d_or
U40 Net-_U25-Pad3_ Net-_U29-Pad3_ Net-_U40-Pad3_ d_and
U46 Net-_U23-Pad3_ Net-_U36-Pad3_ Net-_U46-Pad3_ d_and
U45 Net-_U23-Pad3_ Net-_U38-Pad3_ Net-_U45-Pad3_ d_and
U47 Net-_U37-Pad3_ Net-_U38-Pad3_ Net-_U47-Pad3_ d_and
U39 /A2 Net-_U22-Pad3_ Net-_U39-Pad3_ d_and
U37 Net-_U25-Pad3_ Net-_U23-Pad3_ Net-_U37-Pad3_ d_and
U38 Net-_U27-Pad3_ Net-_U26-Pad3_ Net-_U38-Pad3_ d_or
U32 /S3 /B3 Net-_U32-Pad3_ d_and
U33 /S0 Net-_U30-Pad2_ Net-_U33-Pad3_ d_and
U35 /S2 Net-_U31-Pad2_ Net-_U35-Pad3_ d_and
U42 Net-_U34-Pad3_ Net-_U33-Pad3_ Net-_U42-Pad3_ d_or
U41 Net-_U32-Pad3_ Net-_U35-Pad3_ Net-_U41-Pad3_ d_or
U34 /A3 Net-_U24-Pad3_ Net-_U34-Pad3_ d_or
U36 /A0 Net-_U28-Pad3_ Net-_U36-Pad3_ d_and
U44 Net-_U37-Pad3_ Net-_U36-Pad3_ Net-_U44-Pad3_ d_and
U43 Net-_U39-Pad3_ Net-_U40-Pad3_ Net-_U43-Pad3_ d_or
U55 Net-_U42-Pad3_ Net-_U25-Pad3_ Net-_U55-Pad3_ d_and
U53 Net-_U47-Pad3_ /CN Net-_U53-Pad3_ d_and
U54 Net-_U29-Pad3_ Net-_U46-Pad3_ Net-_U54-Pad3_ d_or
U56 Net-_U49-Pad3_ Net-_U50-Pad3_ Net-_U56-Pad3_ d_or
U52 Net-_U45-Pad3_ /CN Net-_U52-Pad3_ d_and
U51 Net-_U38-Pad3_ /CN Net-_U51-Pad3_ d_and
U50 Net-_U42-Pad3_ Net-_U39-Pad3_ Net-_U50-Pad3_ d_and
U48 Net-_U43-Pad3_ Net-_U44-Pad3_ Net-_U48-Pad3_ d_or
U49 /A3 Net-_U41-Pad3_ Net-_U49-Pad3_ d_and
.end
