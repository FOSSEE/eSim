.title KiCad schematic
U6 /i4 /_ni4 d_inverter
U5 /i3 /_ni3 d_inverter
U2 /i0 /_ni0 d_inverter
U4 /i2 /_ni2 d_inverter
U3 /i1 /_ni1 d_inverter
U119 Net-_U119-Pad1_ /i14 Net-_U119-Pad3_ d_and
U118 Net-_U118-Pad1_ /__ni13 Net-_U118-Pad3_ d_and
U117 Net-_U117-Pad1_ /__ni12 Net-_U117-Pad3_ d_and
U52 /i6 /_ni8 Net-_U116-Pad1_ d_and
U53 /i7 /i9 Net-_U117-Pad1_ d_and
U51 /_ni5 /i8 Net-_U115-Pad1_ d_and
U57 /i11 /i13 Net-_U121-Pad1_ d_and
U56 /i10 /__ni12 Net-_U120-Pad1_ d_and
U55 /_ni9 /i12 Net-_U119-Pad1_ d_and
U54 /i9 /i11 Net-_U118-Pad1_ d_and
U116 Net-_U116-Pad1_ /i11 Net-_U116-Pad3_ d_and
U115 Net-_U115-Pad1_ /i10 Net-_U115-Pad3_ d_and
U121 Net-_U121-Pad1_ /__ni16 Net-_U121-Pad3_ d_and
U120 Net-_U120-Pad1_ /i15 Net-_U120-Pad3_ d_and
U107 Net-_U107-Pad1_ /i4 Net-_U107-Pad3_ d_and
U108 Net-_U108-Pad1_ /i5 Net-_U108-Pad3_ d_and
U109 Net-_U109-Pad1_ /_ni6 Net-_U109-Pad3_ d_and
U106 Net-_U106-Pad1_ /_ni2 Net-_U106-Pad3_ d_and
U45 /i0 /_ni4 Net-_U109-Pad1_ d_and
U44 /i1 /_ni3 Net-_U108-Pad1_ d_and
U43 /_ni0 /i2 Net-_U107-Pad1_ d_and
U42 /i0 /i1 Net-_U106-Pad1_ d_and
U111 Net-_U111-Pad1_ /i6 Net-_U111-Pad3_ d_and
U110 Net-_U110-Pad1_ /_ni4 Net-_U110-Pad3_ d_and
U114 Net-_U114-Pad1_ /_ni9 Net-_U114-Pad3_ d_and
U113 Net-_U113-Pad1_ /_ni8 Net-_U113-Pad3_ d_and
U112 Net-_U112-Pad1_ /i7 Net-_U112-Pad3_ d_and
U50 /i5 /i7 Net-_U114-Pad1_ d_and
U49 /i4 /i6 Net-_U113-Pad1_ d_and
U47 /_ni2 /i5 Net-_U111-Pad1_ d_and
U48 /i3 /_ni5 Net-_U112-Pad1_ d_and
U46 /i2 /i3 Net-_U110-Pad1_ d_and
U17 /i15 /__ni15 d_inverter
U16 /i14 unconnected-_U16-Pad2_ d_inverter
U19 /i17 /__ni17 d_inverter
U18 /i16 /__ni16 d_inverter
U21 /i19 /__ni19 d_inverter
U20 /i18 /__ni18 d_inverter
U11 /i9 /_ni9 d_inverter
U10 /i8 /_ni8 d_inverter
U9 /i7 /_ni7 d_inverter
U15 /i13 /__ni13 d_inverter
U14 /i12 /__ni12 d_inverter
U13 /i11 /__ni11 d_inverter
U12 /i10 /__ni10 d_inverter
U8 /i6 /_ni6 d_inverter
U7 /i5 /_ni5 d_inverter
U302 Net-_U282-Pad2_ /clk /set /reset unconnected-_U302-Pad5_ Net-_U302-Pad6_ d_dff
U318 Net-_U302-Pad6_ unconnected-_U318-Pad2_ dac_bridge_1
U292 Net-_U276-Pad3_ Net-_U292-Pad2_ d_inverter
U282 Net-_U266-Pad3_ Net-_U282-Pad2_ d_inverter
U288 Net-_U272-Pad3_ Net-_U288-Pad2_ d_inverter
U287 Net-_U271-Pad3_ Net-_U287-Pad2_ d_inverter
U272 Net-_U256-Pad3_ Net-_U197-Pad3_ Net-_U272-Pad3_ d_or
U271 Net-_U255-Pad3_ Net-_U201-Pad3_ Net-_U271-Pad3_ d_or
U256 Net-_U240-Pad3_ Net-_U196-Pad3_ Net-_U256-Pad3_ d_or
U255 Net-_U239-Pad3_ Net-_U200-Pad3_ Net-_U255-Pad3_ d_or
U187 Net-_U123-Pad3_ /i0 Net-_U187-Pad3_ d_and
U188 Net-_U124-Pad3_ /i4 Net-_U188-Pad3_ d_and
U186 Net-_U122-Pad3_ /__ni19 Net-_U186-Pad3_ d_and
U190 Net-_U126-Pad3_ /_ni1 Net-_U190-Pad3_ d_and
U189 Net-_U125-Pad3_ /_ni5 Net-_U189-Pad3_ d_and
U244 Net-_U190-Pad3_ Net-_U191-Pad3_ Net-_U244-Pad3_ d_or
U276 Net-_U260-Pad3_ Net-_U193-Pad3_ Net-_U276-Pad3_ d_or
U260 Net-_U244-Pad3_ Net-_U192-Pad3_ Net-_U260-Pad3_ d_or
U266 Net-_U250-Pad3_ Net-_U189-Pad3_ Net-_U266-Pad3_ d_or
U250 Net-_U234-Pad3_ Net-_U188-Pad3_ Net-_U250-Pad3_ d_or
U234 Net-_U186-Pad3_ Net-_U187-Pad3_ Net-_U234-Pad3_ d_or
U240 Net-_U194-Pad3_ Net-_U195-Pad3_ Net-_U240-Pad3_ d_or
U239 Net-_U198-Pad3_ Net-_U199-Pad3_ Net-_U239-Pad3_ d_or
U192 Net-_U128-Pad3_ /_ni3 Net-_U192-Pad3_ d_and
U193 Net-_U129-Pad3_ /_ni7 Net-_U193-Pad3_ d_and
U191 Net-_U127-Pad3_ /i2 Net-_U191-Pad3_ d_and
U197 Net-_U133-Pad3_ /__ni12 Net-_U197-Pad3_ d_and
U198 Net-_U134-Pad3_ /i15 Net-_U198-Pad3_ d_and
U196 Net-_U132-Pad3_ /i11 Net-_U196-Pad3_ d_and
U195 Net-_U131-Pad3_ /__ni10 Net-_U195-Pad3_ d_and
U194 Net-_U130-Pad3_ /i9 Net-_U194-Pad3_ d_and
U201 Net-_U137-Pad3_ /__ni18 Net-_U201-Pad3_ d_and
U200 Net-_U136-Pad3_ /i17 Net-_U200-Pad3_ d_and
U199 Net-_U135-Pad3_ /__ni16 Net-_U199-Pad3_ d_and
U319 Net-_U303-Pad6_ unconnected-_U319-Pad2_ dac_bridge_1
U304 Net-_U288-Pad2_ /clk /set /reset unconnected-_U304-Pad5_ Net-_U304-Pad6_ d_dff
U303 Net-_U292-Pad2_ /clk /set /reset unconnected-_U303-Pad5_ Net-_U303-Pad6_ d_dff
U321 Net-_U305-Pad6_ unconnected-_U321-Pad2_ dac_bridge_1
U320 Net-_U304-Pad6_ unconnected-_U320-Pad2_ dac_bridge_1
U305 Net-_U287-Pad2_ /clk /set /reset unconnected-_U305-Pad5_ Net-_U305-Pad6_ d_dff
U123 Net-_U123-Pad1_ /i18 Net-_U123-Pad3_ d_and
U125 Net-_U125-Pad1_ /_ni0 Net-_U125-Pad3_ d_and
U124 Net-_U124-Pad1_ /i19 Net-_U124-Pad3_ d_and
U122 Net-_U122-Pad1_ /__ni17 Net-_U122-Pad3_ d_and
U61 /i15 /i17 Net-_U125-Pad1_ d_and
U60 /i14 /__ni16 Net-_U124-Pad1_ d_and
U59 /__ni13 /i16 Net-_U123-Pad1_ d_and
U58 /i13 /i15 Net-_U122-Pad1_ d_and
U66 /i1 /i4 Net-_U130-Pad1_ d_and
U65 /i19 /i1 Net-_U129-Pad1_ d_and
U64 /i18 /_ni0 Net-_U128-Pad1_ d_and
U63 /__ni17 /i0 Net-_U127-Pad1_ d_and
U67 /_ni1 /i5 Net-_U131-Pad1_ d_and
U130 Net-_U130-Pad1_ /_ni6 Net-_U130-Pad3_ d_and
U131 Net-_U131-Pad1_ /i7 Net-_U131-Pad3_ d_and
U129 Net-_U129-Pad1_ /_ni4 Net-_U129-Pad3_ d_and
U128 Net-_U128-Pad1_ /i3 Net-_U128-Pad3_ d_and
U127 Net-_U127-Pad1_ /i2 Net-_U127-Pad3_ d_and
U126 Net-_U126-Pad1_ /_ni1 Net-_U126-Pad3_ d_and
U62 /i17 /i19 Net-_U126-Pad1_ d_and
U72 /i9 /__ni11 Net-_U136-Pad1_ d_and
U71 /_ni8 /i11 Net-_U135-Pad1_ d_and
U70 /i8 /i10 Net-_U134-Pad1_ d_and
U69 /i3 /i6 Net-_U133-Pad1_ d_and
U68 /i2 /_ni5 Net-_U132-Pad1_ d_and
U137 Net-_U137-Pad1_ /__ni15 Net-_U137-Pad3_ d_and
U136 Net-_U136-Pad1_ /i14 Net-_U136-Pad3_ d_and
U135 Net-_U135-Pad1_ /i13 Net-_U135-Pad3_ d_and
U73 /i10 /i12 Net-_U137-Pad1_ d_and
U134 Net-_U134-Pad1_ /__ni12 Net-_U134-Pad3_ d_and
U133 Net-_U133-Pad1_ /_ni9 Net-_U133-Pad3_ d_and
U132 Net-_U132-Pad1_ /i8 Net-_U132-Pad3_ d_and
U252 Net-_U236-Pad3_ Net-_U176-Pad3_ Net-_U252-Pad3_ d_or
U236 Net-_U174-Pad3_ Net-_U175-Pad3_ Net-_U236-Pad3_ d_or
U235 Net-_U170-Pad3_ Net-_U171-Pad3_ Net-_U235-Pad3_ d_or
U171 Net-_U107-Pad3_ /_ni5 Net-_U171-Pad3_ d_and
U170 Net-_U106-Pad3_ /i3 Net-_U170-Pad3_ d_and
U173 Net-_U109-Pad3_ /i7 Net-_U173-Pad3_ d_and
U174 Net-_U110-Pad3_ /i8 Net-_U174-Pad3_ d_and
U172 Net-_U108-Pad3_ /i6 Net-_U172-Pad3_ d_and
U269 Net-_U253-Pad3_ Net-_U181-Pad3_ Net-_U269-Pad3_ d_or
U268 Net-_U252-Pad3_ Net-_U177-Pad3_ Net-_U268-Pad3_ d_or
U253 Net-_U237-Pad3_ Net-_U180-Pad3_ Net-_U253-Pad3_ d_or
U267 Net-_U251-Pad3_ Net-_U173-Pad3_ Net-_U267-Pad3_ d_or
U251 Net-_U235-Pad3_ Net-_U172-Pad3_ Net-_U251-Pad3_ d_or
U316 Net-_U300-Pad6_ unconnected-_U316-Pad2_ dac_bridge_1
U317 Net-_U301-Pad6_ unconnected-_U317-Pad2_ dac_bridge_1
U301 Net-_U286-Pad2_ /clk /set /reset unconnected-_U301-Pad5_ Net-_U301-Pad6_ d_dff
U237 Net-_U178-Pad3_ Net-_U179-Pad3_ Net-_U237-Pad3_ d_or
U179 Net-_U115-Pad3_ /__ni13 Net-_U179-Pad3_ d_and
U178 Net-_U114-Pad3_ /i12 Net-_U178-Pad3_ d_and
U177 Net-_U113-Pad3_ /__ni11 Net-_U177-Pad3_ d_and
U176 Net-_U112-Pad3_ /i10 Net-_U176-Pad3_ d_and
U175 Net-_U111-Pad3_ /_ni9 Net-_U175-Pad3_ d_and
U181 Net-_U117-Pad3_ /__ni15 Net-_U181-Pad3_ d_and
U182 Net-_U118-Pad3_ /i16 Net-_U182-Pad3_ d_and
U180 Net-_U116-Pad3_ /i14 Net-_U180-Pad3_ d_and
U270 Net-_U254-Pad3_ Net-_U185-Pad3_ Net-_U270-Pad3_ d_or
U185 Net-_U121-Pad3_ /i18 Net-_U185-Pad3_ d_and
U184 Net-_U120-Pad3_ /i6 Net-_U184-Pad3_ d_and
U183 Net-_U119-Pad3_ /__ni17 Net-_U183-Pad3_ d_and
U254 Net-_U238-Pad3_ Net-_U184-Pad3_ Net-_U254-Pad3_ d_or
U238 Net-_U182-Pad3_ Net-_U183-Pad3_ Net-_U238-Pad3_ d_or
U315 Net-_U299-Pad6_ unconnected-_U315-Pad2_ dac_bridge_1
U314 Net-_U298-Pad6_ unconnected-_U314-Pad2_ dac_bridge_1
U298 Net-_U283-Pad2_ /clk /set /reset unconnected-_U298-Pad5_ Net-_U298-Pad6_ d_dff
U286 Net-_U270-Pad3_ Net-_U286-Pad2_ d_inverter
U300 Net-_U285-Pad2_ /clk /set /reset unconnected-_U300-Pad5_ Net-_U300-Pad6_ d_dff
U285 Net-_U269-Pad3_ Net-_U285-Pad2_ d_inverter
U299 Net-_U284-Pad2_ /clk /set /reset unconnected-_U299-Pad5_ Net-_U299-Pad6_ d_dff
U284 Net-_U268-Pad3_ Net-_U284-Pad2_ d_inverter
U283 Net-_U267-Pad3_ Net-_U283-Pad2_ d_inverter
U88 /i10 /ni12 Net-_U152-Pad1_ d_and
U87 /ni9 /i12 Net-_U151-Pad1_ d_and
U86 /i9 /i11 Net-_U150-Pad1_ d_and
U85 /i7 /i9 Net-_U149-Pad1_ d_and
U84 /i6 /ni8 Net-_U148-Pad1_ d_and
U80 /i3 /ni5 Net-_U144-Pad1_ d_and
U79 /ni2 /i5 Net-_U143-Pad1_ d_and
U28 /i6 /ni6 d_inverter
U27 /i5 /ni5 d_inverter
U30 /i8 /ni8 d_inverter
U29 /i7 /ni7 d_inverter
U83 /ni5 /i8 Net-_U147-Pad1_ d_and
U82 /i5 /i7 Net-_U146-Pad1_ d_and
U81 /i4 /i6 Net-_U145-Pad1_ d_and
U26 /i4 /ni4 d_inverter
U25 /i3 /ni3 d_inverter
U24 /i2 /ni2 d_inverter
U23 /i1 /ni1 d_inverter
U22 /i0 /ni0 d_inverter
U77 /i0 /ni4 Net-_U141-Pad1_ d_and
U78 /i2 /i3 Net-_U142-Pad1_ d_and
U76 /i1 /ni3 Net-_U140-Pad1_ d_and
U31 /i9 /ni9 d_inverter
U33 /i11 /ni11 d_inverter
U32 /i10 /ni10 d_inverter
U39 /i17 /ni17 d_inverter
U38 /i16 /ni16 d_inverter
U37 /i15 /ni15 d_inverter
U41 /i19 /ni19 d_inverter
U40 /i18 /ni18 d_inverter
U1 /i0 /i1 /i2 /i3 /i4 /i5 /i6 /i7 /i8 /i9 /i10 /i11 /i12 /i13 /i14 /i15 /i16 /i17 /i18 /i19 /clk /set /reset Net-_U1-Pad24_ Net-_U1-Pad25_ Net-_U1-Pad26_ PORT
U34 /i12 /ni12 d_inverter
U35 /i13 /ni13 d_inverter
U36 /i14 unconnected-_U36-Pad2_ d_inverter
U248 Net-_U226-Pad3_ Net-_U227-Pad3_ Net-_U248-Pad3_ d_or
U264 Net-_U248-Pad3_ Net-_U228-Pad3_ Net-_U264-Pad3_ d_or
U233 Net-_U169-Pad3_ /ni18 Net-_U233-Pad3_ d_and
U263 Net-_U247-Pad3_ Net-_U232-Pad3_ Net-_U263-Pad3_ d_or
U247 Net-_U230-Pad3_ Net-_U231-Pad3_ Net-_U247-Pad3_ d_or
U257 Net-_U241-Pad3_ Net-_U220-Pad3_ Net-_U257-Pad3_ d_or
U265 Net-_U249-Pad3_ Net-_U224-Pad3_ Net-_U265-Pad3_ d_or
U249 Net-_U222-Pad3_ Net-_U223-Pad3_ Net-_U249-Pad3_ d_or
U297 Net-_U281-Pad3_ Net-_U297-Pad2_ d_inverter
U281 Net-_U265-Pad3_ Net-_U225-Pad3_ Net-_U281-Pad3_ d_or
U280 Net-_U264-Pad3_ Net-_U229-Pad3_ Net-_U280-Pad3_ d_or
U279 Net-_U263-Pad3_ Net-_U233-Pad3_ Net-_U279-Pad3_ d_or
U289 Net-_U273-Pad3_ Net-_U289-Pad2_ d_inverter
U273 Net-_U257-Pad3_ Net-_U221-Pad3_ Net-_U273-Pad3_ d_or
U296 Net-_U280-Pad3_ Net-_U296-Pad2_ d_inverter
U295 Net-_U279-Pad3_ Net-_U295-Pad2_ d_inverter
U241 Net-_U218-Pad3_ Net-_U219-Pad3_ Net-_U241-Pad3_ d_or
U313 Net-_U295-Pad2_ /clk /set /reset Net-_U1-Pad26_ unconnected-_U313-Pad6_ d_dff
U312 Net-_U296-Pad2_ /clk /set /reset unconnected-_U312-Pad5_ unconnected-_U312-Pad6_ d_dff
U311 Net-_U297-Pad2_ /clk /set /reset unconnected-_U311-Pad5_ unconnected-_U311-Pad6_ d_dff
U310 Net-_U289-Pad2_ /clk /set /reset unconnected-_U310-Pad5_ unconnected-_U310-Pad6_ d_dff
U206 Net-_U142-Pad3_ /i8 Net-_U206-Pad3_ d_and
U207 Net-_U143-Pad3_ /ni9 Net-_U207-Pad3_ d_and
U205 Net-_U141-Pad3_ /i7 Net-_U205-Pad3_ d_and
U204 Net-_U140-Pad3_ /i6 Net-_U204-Pad3_ d_and
U203 Net-_U139-Pad3_ /ni5 Net-_U203-Pad3_ d_and
U202 Net-_U138-Pad3_ /i3 Net-_U202-Pad3_ d_and
U210 Net-_U146-Pad3_ /i12 Net-_U210-Pad3_ d_and
U209 Net-_U145-Pad3_ /ni11 Net-_U209-Pad3_ d_and
U208 Net-_U144-Pad3_ /i10 Net-_U208-Pad3_ d_and
U75 /ni0 /i2 Net-_U139-Pad1_ d_and
U74 /i0 /i1 Net-_U138-Pad1_ d_and
U139 Net-_U139-Pad1_ /i4 Net-_U139-Pad3_ d_and
U140 Net-_U140-Pad1_ /i5 Net-_U140-Pad3_ d_and
U138 Net-_U138-Pad1_ /ni2 Net-_U138-Pad3_ d_and
U142 Net-_U142-Pad1_ /ni4 Net-_U142-Pad3_ d_and
U141 Net-_U141-Pad1_ /ni6 Net-_U141-Pad3_ d_and
U149 Net-_U149-Pad1_ /ni12 Net-_U149-Pad3_ d_and
U148 Net-_U148-Pad1_ /i11 Net-_U148-Pad3_ d_and
U147 Net-_U147-Pad1_ /i10 Net-_U147-Pad3_ d_and
U144 Net-_U144-Pad1_ /i7 Net-_U144-Pad3_ d_and
U146 Net-_U146-Pad1_ /ni9 Net-_U146-Pad3_ d_and
U145 Net-_U145-Pad1_ /ni8 Net-_U145-Pad3_ d_and
U143 Net-_U143-Pad1_ /i6 Net-_U143-Pad3_ d_and
U150 Net-_U150-Pad1_ /ni13 Net-_U150-Pad3_ d_and
U213 Net-_U149-Pad3_ /ni15 Net-_U213-Pad3_ d_and
U212 Net-_U148-Pad3_ /i14 Net-_U212-Pad3_ d_and
U211 Net-_U147-Pad3_ /ni13 Net-_U211-Pad3_ d_and
U152 Net-_U152-Pad1_ /i15 Net-_U152-Pad3_ d_and
U151 Net-_U151-Pad1_ /i14 Net-_U151-Pad3_ d_and
U215 Net-_U151-Pad3_ /ni17 Net-_U215-Pad3_ d_and
U216 Net-_U152-Pad3_ /i6 Net-_U216-Pad3_ d_and
U214 Net-_U150-Pad3_ /i16 Net-_U214-Pad3_ d_and
U307 Net-_U291-Pad2_ /clk /set /reset unconnected-_U307-Pad5_ unconnected-_U307-Pad6_ d_dff
U308 Net-_U293-Pad2_ /clk /set /reset unconnected-_U308-Pad5_ unconnected-_U308-Pad6_ d_dff
U306 Net-_U290-Pad2_ /clk /set /reset Net-_U1-Pad24_ unconnected-_U306-Pad6_ d_dff
U309 Net-_U294-Pad2_ /clk /set /reset Net-_U1-Pad25_ unconnected-_U309-Pad6_ d_dff
U291 Net-_U275-Pad3_ Net-_U291-Pad2_ d_inverter
U275 Net-_U259-Pad3_ Net-_U209-Pad3_ Net-_U275-Pad3_ d_or
U290 Net-_U274-Pad3_ Net-_U290-Pad2_ d_inverter
U274 Net-_U258-Pad3_ Net-_U205-Pad3_ Net-_U274-Pad3_ d_or
U294 Net-_U278-Pad3_ Net-_U294-Pad2_ d_inverter
U293 Net-_U277-Pad3_ Net-_U293-Pad2_ d_inverter
U278 Net-_U262-Pad3_ Net-_U217-Pad3_ Net-_U278-Pad3_ d_or
U277 Net-_U261-Pad3_ Net-_U213-Pad3_ Net-_U277-Pad3_ d_or
U259 Net-_U243-Pad3_ Net-_U208-Pad3_ Net-_U259-Pad3_ d_or
U258 Net-_U242-Pad3_ Net-_U204-Pad3_ Net-_U258-Pad3_ d_or
U242 Net-_U202-Pad3_ Net-_U203-Pad3_ Net-_U242-Pad3_ d_or
U262 Net-_U246-Pad3_ Net-_U216-Pad3_ Net-_U262-Pad3_ d_or
U246 Net-_U214-Pad3_ Net-_U215-Pad3_ Net-_U246-Pad3_ d_or
U261 Net-_U245-Pad3_ Net-_U212-Pad3_ Net-_U261-Pad3_ d_or
U245 Net-_U210-Pad3_ Net-_U211-Pad3_ Net-_U245-Pad3_ d_or
U243 Net-_U206-Pad3_ Net-_U207-Pad3_ Net-_U243-Pad3_ d_or
U101 /i3 /i6 Net-_U101-Pad3_ d_and
U162 Net-_U162-Pad1_ /ni6 Net-_U162-Pad3_ d_and
U161 Net-_U161-Pad1_ /ni4 Net-_U161-Pad3_ d_and
U160 Net-_U160-Pad1_ /i3 Net-_U160-Pad3_ d_and
U97 /i19 /i1 Net-_U161-Pad1_ d_and
U96 /i18 /ni0 Net-_U160-Pad1_ d_and
U229 Net-_U165-Pad3_ /ni12 Net-_U229-Pad3_ d_and
U230 Net-_U166-Pad3_ /i15 Net-_U230-Pad3_ d_and
U231 Net-_U167-Pad3_ /ni16 Net-_U231-Pad3_ d_and
U232 Net-_U168-Pad3_ /i17 Net-_U232-Pad3_ d_and
U228 Net-_U164-Pad3_ /i11 Net-_U228-Pad3_ d_and
U225 Net-_U161-Pad3_ /ni7 Net-_U225-Pad3_ d_and
U227 Net-_U163-Pad3_ /ni10 Net-_U227-Pad3_ d_and
U226 Net-_U162-Pad3_ /i9 Net-_U226-Pad3_ d_and
U224 Net-_U160-Pad3_ /ni3 Net-_U224-Pad3_ d_and
U165 Net-_U101-Pad3_ /ni9 Net-_U165-Pad3_ d_and
U164 Net-_U100-Pad3_ /i8 Net-_U164-Pad3_ d_and
U163 Net-_U163-Pad1_ /i7 Net-_U163-Pad3_ d_and
U91 /ni13 /i16 Net-_U155-Pad1_ d_and
U90 /i13 /i15 Net-_U154-Pad1_ d_and
U89 /i11 /i13 Net-_U153-Pad1_ d_and
U95 /ni17 /i0 Net-_U159-Pad1_ d_and
U94 /i17 /i19 Net-_U158-Pad1_ d_and
U93 /i15 /i17 Net-_U157-Pad1_ d_and
U92 /i14 /ni16 Net-_U156-Pad1_ d_and
U99 /ni1 /i5 Net-_U163-Pad1_ d_and
U100 /i2 /ni5 Net-_U100-Pad3_ d_and
U98 /i1 /i4 Net-_U162-Pad1_ d_and
U155 Net-_U155-Pad1_ /i18 Net-_U155-Pad3_ d_and
U154 Net-_U154-Pad1_ /ni17 Net-_U154-Pad3_ d_and
U153 Net-_U153-Pad1_ /ni16 Net-_U153-Pad3_ d_and
U218 Net-_U154-Pad3_ /ni19 Net-_U218-Pad3_ d_and
U219 Net-_U155-Pad3_ /i0 Net-_U219-Pad3_ d_and
U217 Net-_U153-Pad3_ /i18 Net-_U217-Pad3_ d_and
U158 Net-_U158-Pad1_ /ni1 Net-_U158-Pad3_ d_and
U157 Net-_U157-Pad1_ /ni0 Net-_U157-Pad3_ d_and
U159 Net-_U159-Pad1_ /i2 Net-_U159-Pad3_ d_and
U156 Net-_U156-Pad1_ /i19 Net-_U156-Pad3_ d_and
U223 Net-_U159-Pad3_ /i2 Net-_U223-Pad3_ d_and
U221 Net-_U157-Pad3_ /ni5 Net-_U221-Pad3_ d_and
U222 Net-_U158-Pad3_ /ni1 Net-_U222-Pad3_ d_and
U220 Net-_U156-Pad3_ /i4 Net-_U220-Pad3_ d_and
U103 /ni8 /i11 Net-_U103-Pad3_ d_and
U102 /i8 /i10 Net-_U102-Pad3_ d_and
U105 /i10 /i12 Net-_U105-Pad3_ d_and
U104 /i9 /ni11 Net-_U104-Pad3_ d_and
U167 Net-_U103-Pad3_ /i13 Net-_U167-Pad3_ d_and
U169 Net-_U105-Pad3_ /ni15 Net-_U169-Pad3_ d_and
U168 Net-_U104-Pad3_ /i14 Net-_U168-Pad3_ d_and
U166 Net-_U102-Pad3_ /ni12 Net-_U166-Pad3_ d_and
.end
