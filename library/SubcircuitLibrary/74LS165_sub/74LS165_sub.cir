.title KiCad schematic
U5 Net-_U1-Pad4_ Net-_U1-Pad8_ Net-_U17-Pad1_ d_and
U6 Net-_U1-Pad5_ Net-_U1-Pad8_ Net-_U16-Pad1_ d_and
U2 Net-_U1-Pad1_ Net-_U1-Pad8_ Net-_U10-Pad1_ d_and
U3 Net-_U1-Pad2_ Net-_U1-Pad8_ Net-_U14-Pad1_ d_and
U1 Net-_U1-Pad1_ Net-_U1-Pad2_ Net-_U1-Pad3_ Net-_U1-Pad4_ Net-_U1-Pad5_ Net-_U1-Pad6_ Net-_U1-Pad7_ Net-_U1-Pad8_ Net-_U1-Pad9_ Net-_U1-Pad10_ Net-_U1-Pad11_ Net-_U1-Pad12_ PORT
U4 Net-_U1-Pad3_ Net-_U1-Pad8_ Net-_U15-Pad1_ d_and
U20 Net-_U17-Pad3_ Net-_U1-Pad9_ unconnected-_U20-Pad3_ unconnected-_U20-Pad4_ Net-_U16-Pad2_ unconnected-_U20-Pad6_ d_dff
U19 Net-_U15-Pad3_ Net-_U1-Pad9_ unconnected-_U19-Pad3_ unconnected-_U19-Pad4_ Net-_U17-Pad2_ unconnected-_U19-Pad6_ d_dff
U22 Net-_U12-Pad3_ Net-_U1-Pad9_ unconnected-_U22-Pad3_ unconnected-_U22-Pad4_ Net-_U13-Pad2_ unconnected-_U22-Pad6_ d_dff
U21 Net-_U1-Pad9_ Net-_U1-Pad9_ unconnected-_U21-Pad3_ unconnected-_U21-Pad4_ Net-_U12-Pad2_ unconnected-_U21-Pad6_ d_dff
U24 Net-_U11-Pad3_ Net-_U1-Pad9_ unconnected-_U24-Pad3_ unconnected-_U24-Pad4_ Net-_U1-Pad11_ unconnected-_U24-Pad6_ d_dff
U23 Net-_U13-Pad3_ Net-_U1-Pad9_ unconnected-_U23-Pad3_ unconnected-_U23-Pad4_ Net-_U11-Pad2_ unconnected-_U23-Pad6_ d_dff
U25 Net-_U1-Pad11_ Net-_U1-Pad12_ d_inverter
U10 Net-_U10-Pad1_ Net-_U1-Pad9_ unconnected-_U10-Pad3_ unconnected-_U10-Pad4_ Net-_U10-Pad5_ unconnected-_U10-Pad6_ d_dff
U18 Net-_U14-Pad3_ Net-_U1-Pad9_ unconnected-_U18-Pad3_ unconnected-_U18-Pad4_ Net-_U15-Pad2_ unconnected-_U18-Pad6_ d_dff
U15 Net-_U15-Pad1_ Net-_U15-Pad2_ Net-_U15-Pad3_ d_or
U14 Net-_U14-Pad1_ Net-_U10-Pad5_ Net-_U14-Pad3_ d_or
U16 Net-_U16-Pad1_ Net-_U16-Pad2_ Net-_U1-Pad9_ d_or
U17 Net-_U17-Pad1_ Net-_U17-Pad2_ Net-_U17-Pad3_ d_or
U12 Net-_U12-Pad1_ Net-_U12-Pad2_ Net-_U12-Pad3_ d_or
U9 Net-_U1-Pad10_ Net-_U1-Pad8_ Net-_U11-Pad1_ d_and
U7 Net-_U1-Pad6_ Net-_U1-Pad8_ Net-_U12-Pad1_ d_and
U8 Net-_U1-Pad7_ Net-_U1-Pad8_ Net-_U13-Pad1_ d_and
U11 Net-_U11-Pad1_ Net-_U11-Pad2_ Net-_U11-Pad3_ d_or
U13 Net-_U13-Pad1_ Net-_U13-Pad2_ Net-_U13-Pad3_ d_or
.end
