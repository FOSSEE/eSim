.title KiCad schematic
U1 Net-_U1-Pad1_ Net-_U1-Pad2_ Net-_U1-Pad3_ Net-_U1-Pad4_ Net-_U1-Pad5_ Net-_U1-Pad6_ unconnected-_U1-Pad7_ Net-_U1-Pad8_ Net-_U1-Pad9_ Net-_U1-Pad10_ Net-_U1-Pad11_ Net-_U1-Pad12_ Net-_U1-Pad13_ unconnected-_U1-Pad14_ PORT
U4 Net-_U1-Pad1_ Net-_U1-Pad2_ Net-_U4-Pad3_ d_and
U6 Net-_U4-Pad3_ Net-_U10-Pad2_ unconnected-_U6-Pad3_ Net-_U10-Pad4_ Net-_U6-Pad5_ unconnected-_U6-Pad6_ d_dff
U5 Net-_U3-Pad2_ Net-_U10-Pad4_ d_inverter
U3 Net-_U1-Pad9_ Net-_U3-Pad2_ d_inverter
U2 Net-_U1-Pad8_ Net-_U10-Pad2_ d_inverter
U8 Net-_U6-Pad5_ Net-_U10-Pad2_ unconnected-_U8-Pad3_ Net-_U10-Pad4_ Net-_U10-Pad1_ unconnected-_U8-Pad6_ d_dff
U9 Net-_U10-Pad1_ Net-_U1-Pad4_ d_buffer
U7 Net-_U6-Pad5_ Net-_U1-Pad3_ d_buffer
U10 Net-_U10-Pad1_ Net-_U10-Pad2_ unconnected-_U10-Pad3_ Net-_U10-Pad4_ Net-_U10-Pad5_ unconnected-_U10-Pad6_ d_dff
U12 Net-_U10-Pad5_ Net-_U10-Pad2_ unconnected-_U12-Pad3_ Net-_U10-Pad4_ Net-_U12-Pad5_ unconnected-_U12-Pad6_ d_dff
U11 Net-_U10-Pad5_ Net-_U1-Pad5_ d_buffer
U18 Net-_U16-Pad5_ Net-_U10-Pad2_ unconnected-_U18-Pad3_ Net-_U10-Pad4_ Net-_U18-Pad5_ unconnected-_U18-Pad6_ d_dff
U19 Net-_U18-Pad5_ Net-_U1-Pad12_ d_buffer
U17 Net-_U16-Pad5_ Net-_U1-Pad11_ d_buffer
U21 Net-_U20-Pad5_ Net-_U1-Pad13_ d_buffer
U20 Net-_U18-Pad5_ Net-_U10-Pad2_ unconnected-_U20-Pad3_ Net-_U10-Pad4_ Net-_U20-Pad5_ unconnected-_U20-Pad6_ d_dff
U13 Net-_U12-Pad5_ Net-_U1-Pad6_ d_buffer
U15 Net-_U14-Pad5_ Net-_U1-Pad10_ d_buffer
U16 Net-_U14-Pad5_ Net-_U10-Pad2_ unconnected-_U16-Pad3_ Net-_U10-Pad4_ Net-_U16-Pad5_ unconnected-_U16-Pad6_ d_dff
U14 Net-_U12-Pad5_ Net-_U10-Pad2_ unconnected-_U14-Pad3_ Net-_U10-Pad4_ Net-_U14-Pad5_ unconnected-_U14-Pad6_ d_dff
.end
