.title KiCad schematic
Q8 Net-_Q1-Pad1_ Net-_Q8-Pad2_ Net-_Q6-Pad3_ eSim_NPN
Q6 Net-_Q6-Pad1_ Net-_Q10-Pad1_ Net-_Q6-Pad3_ eSim_PNP
U1 Net-_Q8-Pad2_ Net-_Q1-Pad2_ Net-_Q3-Pad3_ Net-_Q11-Pad3_ Net-_Q29-Pad3_ Net-_Q27-Pad2_ Net-_Q34-Pad2_ Net-_Q33-Pad3_ Net-_Q30-Pad1_ Net-_Q49-Pad3_ unconnected-_U1-Pad11_ Net-_Q23-Pad3_ Net-_Q12-Pad3_ Net-_Q7-Pad3_ PORT
Q5 Net-_Q1-Pad1_ Net-_Q1-Pad1_ Net-_Q12-Pad3_ eSim_PNP
Q2 Net-_Q2-Pad1_ Net-_Q10-Pad1_ Net-_Q1-Pad3_ eSim_PNP
Q1 Net-_Q1-Pad1_ Net-_Q1-Pad2_ Net-_Q1-Pad3_ eSim_NPN
Q25 Net-_Q12-Pad3_ Net-_Q17-Pad1_ Net-_Q23-Pad2_ eSim_NPN
Q17 Net-_Q17-Pad1_ Net-_Q12-Pad1_ Net-_Q12-Pad3_ eSim_PNP
Q15 Net-_C1-Pad1_ Net-_Q12-Pad1_ Net-_Q12-Pad3_ eSim_PNP
Q23 Net-_Q17-Pad1_ Net-_Q23-Pad2_ Net-_Q23-Pad3_ eSim_NPN
Q19 Net-_Q17-Pad1_ Net-_Q17-Pad1_ Net-_Q19-Pad3_ eSim_NPN
Q7 Net-_Q6-Pad1_ Net-_Q3-Pad2_ Net-_Q7-Pad3_ eSim_NPN
R4 Net-_C1-Pad2_ Net-_Q6-Pad1_ 300
R5 Net-_Q11-Pad3_ Net-_Q10-Pad3_ 5k
C1 Net-_C1-Pad1_ Net-_C1-Pad2_ 30p
Q11 Net-_Q10-Pad2_ Net-_Q10-Pad2_ Net-_Q11-Pad3_ eSim_NPN
Q10 Net-_Q10-Pad1_ Net-_Q10-Pad2_ Net-_Q10-Pad3_ eSim_NPN
Q13 Net-_C1-Pad2_ Net-_Q13-Pad2_ Net-_Q11-Pad3_ eSim_NPN
Q3 Net-_Q2-Pad1_ Net-_Q3-Pad2_ Net-_Q3-Pad3_ eSim_NPN
R1 Net-_Q11-Pad3_ Net-_Q3-Pad3_ 1k
R3 Net-_Q11-Pad3_ Net-_Q7-Pad3_ 1k
R2 Net-_Q11-Pad3_ Net-_Q3-Pad2_ 50k
R6 Net-_Q10-Pad2_ Net-_Q12-Pad1_ 40k
Q4 Net-_Q12-Pad3_ Net-_Q2-Pad1_ Net-_Q3-Pad2_ eSim_NPN
Q9 Net-_Q10-Pad1_ Net-_Q1-Pad1_ Net-_Q12-Pad3_ eSim_PNP
Q12 Net-_Q12-Pad1_ Net-_Q12-Pad1_ Net-_Q12-Pad3_ eSim_PNP
Q21 Net-_Q17-Pad1_ Net-_Q19-Pad3_ Net-_Q21-Pad3_ eSim_NPN
R9 Net-_Q21-Pad3_ Net-_Q19-Pad3_ 50k
R11 Net-_Q23-Pad2_ Net-_Q23-Pad3_ 27
R12 Net-_Q23-Pad3_ Net-_Q24-Pad2_ 22
Q26 Net-_Q11-Pad3_ Net-_Q21-Pad3_ Net-_Q24-Pad2_ eSim_PNP
Q20 Net-_Q11-Pad3_ Net-_C1-Pad1_ Net-_C1-Pad2_ eSim_PNP
Q22 Net-_Q11-Pad3_ Net-_C1-Pad1_ Net-_Q21-Pad3_ eSim_PNP
Q24 Net-_Q13-Pad2_ Net-_Q24-Pad2_ Net-_Q23-Pad3_ eSim_PNP
Q18 Net-_Q13-Pad2_ Net-_Q13-Pad2_ Net-_Q11-Pad3_ eSim_NPN
R10 Net-_Q11-Pad3_ Net-_Q13-Pad2_ 50k
R7 Net-_Q11-Pad3_ Net-_Q14-Pad3_ 50k
R8 Net-_Q11-Pad3_ Net-_Q16-Pad3_ 100
Q14 Net-_Q12-Pad3_ Net-_C1-Pad2_ Net-_Q14-Pad3_ eSim_NPN
Q16 Net-_C1-Pad1_ Net-_Q14-Pad3_ Net-_Q16-Pad3_ eSim_NPN
R24 Net-_Q49-Pad3_ Net-_Q50-Pad2_ 22
Q47 Net-_Q43-Pad1_ Net-_Q45-Pad3_ Net-_Q47-Pad3_ eSim_NPN
Q45 Net-_Q43-Pad1_ Net-_Q43-Pad1_ Net-_Q45-Pad3_ eSim_NPN
Q49 Net-_Q43-Pad1_ Net-_Q49-Pad2_ Net-_Q49-Pad3_ eSim_NPN
R23 Net-_Q49-Pad2_ Net-_Q49-Pad3_ 27
Q51 Net-_Q30-Pad1_ Net-_Q43-Pad1_ Net-_Q49-Pad2_ eSim_NPN
Q31 Net-_Q27-Pad1_ Net-_Q27-Pad1_ Net-_Q30-Pad1_ eSim_PNP
Q44 Net-_Q39-Pad2_ Net-_Q39-Pad2_ Net-_Q11-Pad3_ eSim_NPN
Q46 Net-_Q11-Pad3_ Net-_C2-Pad1_ Net-_C2-Pad2_ eSim_PNP
Q48 Net-_Q11-Pad3_ Net-_C2-Pad1_ Net-_Q47-Pad3_ eSim_PNP
R22 Net-_Q11-Pad3_ Net-_Q39-Pad2_ 50k
Q50 Net-_Q39-Pad2_ Net-_Q50-Pad2_ Net-_Q49-Pad3_ eSim_PNP
Q52 Net-_Q11-Pad3_ Net-_Q47-Pad3_ Net-_Q50-Pad2_ eSim_PNP
R21 Net-_Q47-Pad3_ Net-_Q45-Pad3_ 50k
Q43 Net-_Q43-Pad1_ Net-_Q38-Pad1_ Net-_Q30-Pad1_ eSim_PNP
Q41 Net-_C2-Pad1_ Net-_Q38-Pad1_ Net-_Q30-Pad1_ eSim_PNP
Q38 Net-_Q38-Pad1_ Net-_Q38-Pad1_ Net-_Q30-Pad1_ eSim_PNP
R18 Net-_Q36-Pad2_ Net-_Q38-Pad1_ 40k
C2 Net-_C2-Pad1_ Net-_C2-Pad2_ 30p
Q35 Net-_Q28-Pad2_ Net-_Q27-Pad1_ Net-_Q30-Pad1_ eSim_PNP
R16 Net-_C2-Pad2_ Net-_Q32-Pad1_ 300
Q36 Net-_Q28-Pad2_ Net-_Q36-Pad2_ Net-_Q36-Pad3_ eSim_NPN
R17 Net-_Q11-Pad3_ Net-_Q36-Pad3_ 5k
Q34 Net-_Q27-Pad1_ Net-_Q34-Pad2_ Net-_Q32-Pad3_ eSim_NPN
Q28 Net-_Q28-Pad1_ Net-_Q28-Pad2_ Net-_Q27-Pad3_ eSim_PNP
Q32 Net-_Q32-Pad1_ Net-_Q28-Pad2_ Net-_Q32-Pad3_ eSim_PNP
Q27 Net-_Q27-Pad1_ Net-_Q27-Pad2_ Net-_Q27-Pad3_ eSim_NPN
Q40 Net-_Q30-Pad1_ Net-_C2-Pad2_ Net-_Q40-Pad3_ eSim_NPN
Q42 Net-_C2-Pad1_ Net-_Q40-Pad3_ Net-_Q42-Pad3_ eSim_NPN
Q39 Net-_C2-Pad2_ Net-_Q39-Pad2_ Net-_Q11-Pad3_ eSim_NPN
R19 Net-_Q11-Pad3_ Net-_Q40-Pad3_ 50k
Q37 Net-_Q36-Pad2_ Net-_Q36-Pad2_ Net-_Q11-Pad3_ eSim_NPN
R20 Net-_Q11-Pad3_ Net-_Q42-Pad3_ 100
R14 Net-_Q11-Pad3_ Net-_Q29-Pad2_ 50k
Q30 Net-_Q30-Pad1_ Net-_Q28-Pad1_ Net-_Q29-Pad2_ eSim_NPN
Q29 Net-_Q28-Pad1_ Net-_Q29-Pad2_ Net-_Q29-Pad3_ eSim_NPN
R15 Net-_Q11-Pad3_ Net-_Q33-Pad3_ 1k
Q33 Net-_Q32-Pad1_ Net-_Q29-Pad2_ Net-_Q33-Pad3_ eSim_NPN
R13 Net-_Q11-Pad3_ Net-_Q29-Pad3_ 1k
.end
