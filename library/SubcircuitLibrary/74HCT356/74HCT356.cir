.title KiCad schematic
U27 Net-_U26-Pad3_ Net-_U1-Pad18_ d_inverter
U25 Net-_U24-Pad2_ Net-_U25-Pad2_ Net-_U1-Pad19_ d_tristate
U26 Net-_U24-Pad2_ Net-_U25-Pad2_ Net-_U26-Pad3_ d_tristate
U1 Net-_U1-Pad1_ Net-_U1-Pad2_ Net-_U1-Pad3_ Net-_U1-Pad4_ Net-_U1-Pad5_ Net-_U1-Pad6_ Net-_U1-Pad7_ Net-_U1-Pad8_ Net-_U10-Pad2_ unconnected-_U1-Pad10_ Net-_U1-Pad11_ Net-_U1-Pad12_ Net-_U1-Pad13_ Net-_U1-Pad14_ Net-_U1-Pad15_ Net-_U1-Pad16_ Net-_U1-Pad17_ Net-_U1-Pad18_ Net-_U1-Pad19_ unconnected-_U1-Pad20_ PORT
U24 Net-_U23-Pad3_ Net-_U24-Pad2_ d_inverter
U10 Net-_U1-Pad5_ Net-_U10-Pad2_ unconnected-_U10-Pad3_ unconnected-_U10-Pad4_ unconnected-_U10-Pad5_ Net-_U10-Pad6_ d_dff
U11 Net-_U1-Pad6_ Net-_U10-Pad2_ unconnected-_U11-Pad3_ unconnected-_U11-Pad4_ unconnected-_U11-Pad5_ Net-_U11-Pad6_ d_dff
X6 Net-_U16-Pad5_ Net-_U15-Pad5_ Net-_U14-Pad6_ Net-_U10-Pad6_ Net-_U20-Pad2_ 4_and
X7 Net-_U16-Pad6_ Net-_U15-Pad5_ Net-_U14-Pad6_ Net-_U11-Pad6_ Net-_U21-Pad2_ 4_and
U9 Net-_U1-Pad4_ Net-_U10-Pad2_ unconnected-_U9-Pad3_ unconnected-_U9-Pad4_ unconnected-_U9-Pad5_ Net-_U9-Pad6_ d_dff
U8 Net-_U1-Pad3_ Net-_U10-Pad2_ unconnected-_U8-Pad3_ unconnected-_U8-Pad4_ unconnected-_U8-Pad5_ Net-_U8-Pad6_ d_dff
U7 Net-_U1-Pad2_ Net-_U10-Pad2_ unconnected-_U7-Pad3_ unconnected-_U7-Pad4_ unconnected-_U7-Pad5_ Net-_U7-Pad6_ d_dff
U6 Net-_U1-Pad1_ Net-_U10-Pad2_ unconnected-_U6-Pad3_ unconnected-_U6-Pad4_ unconnected-_U6-Pad5_ Net-_U6-Pad6_ d_dff
U18 Net-_U17-Pad3_ Net-_U18-Pad2_ Net-_U18-Pad3_ d_or
U20 Net-_U19-Pad3_ Net-_U20-Pad2_ Net-_U20-Pad3_ d_or
U22 Net-_U21-Pad3_ Net-_U22-Pad2_ Net-_U22-Pad3_ d_or
X3 Net-_U16-Pad6_ Net-_U14-Pad5_ Net-_U15-Pad5_ Net-_U7-Pad6_ Net-_U17-Pad2_ 4_and
X4 Net-_U14-Pad5_ Net-_U16-Pad5_ Net-_U15-Pad6_ Net-_U8-Pad6_ Net-_U18-Pad2_ 4_and
X5 Net-_U16-Pad6_ Net-_U14-Pad5_ Net-_U15-Pad6_ Net-_U9-Pad6_ Net-_U19-Pad2_ 4_and
X2 Net-_U14-Pad5_ Net-_U16-Pad5_ Net-_U15-Pad5_ Net-_U6-Pad6_ Net-_U17-Pad1_ 4_and
U14 Net-_U1-Pad12_ Net-_U14-Pad2_ unconnected-_U14-Pad3_ unconnected-_U14-Pad4_ Net-_U14-Pad5_ Net-_U14-Pad6_ d_dlatch
U12 Net-_U1-Pad7_ Net-_U10-Pad2_ unconnected-_U12-Pad3_ unconnected-_U12-Pad4_ unconnected-_U12-Pad5_ Net-_U12-Pad6_ d_dff
U13 Net-_U1-Pad8_ Net-_U10-Pad2_ unconnected-_U13-Pad3_ unconnected-_U13-Pad4_ unconnected-_U13-Pad5_ Net-_U13-Pad6_ d_dff
U23 Net-_U22-Pad3_ Net-_U23-Pad2_ Net-_U23-Pad3_ d_or
U21 Net-_U20-Pad3_ Net-_U21-Pad2_ Net-_U21-Pad3_ d_or
U17 Net-_U17-Pad1_ Net-_U17-Pad2_ Net-_U17-Pad3_ d_or
U19 Net-_U18-Pad3_ Net-_U19-Pad2_ Net-_U19-Pad3_ d_or
X8 Net-_U16-Pad5_ Net-_U15-Pad6_ Net-_U14-Pad6_ Net-_U12-Pad6_ Net-_U22-Pad2_ 4_and
X9 Net-_U16-Pad6_ Net-_U15-Pad6_ Net-_U14-Pad6_ Net-_U13-Pad6_ Net-_U23-Pad2_ 4_and
U15 Net-_U1-Pad13_ Net-_U14-Pad2_ unconnected-_U15-Pad3_ unconnected-_U15-Pad4_ Net-_U15-Pad5_ Net-_U15-Pad6_ d_dlatch
U16 Net-_U1-Pad14_ Net-_U14-Pad2_ unconnected-_U16-Pad3_ unconnected-_U16-Pad4_ Net-_U16-Pad5_ Net-_U16-Pad6_ d_dlatch
U2 Net-_U1-Pad11_ Net-_U14-Pad2_ d_inverter
X1 Net-_U4-Pad2_ Net-_U3-Pad2_ Net-_U1-Pad17_ Net-_U25-Pad2_ 3_and
U3 Net-_U1-Pad16_ Net-_U3-Pad2_ d_inverter
U4 Net-_U1-Pad15_ Net-_U4-Pad2_ d_inverter
.end
