.title KiCad schematic
U32 Net-_U24-Pad3_ Net-_U1-Pad9_ d_inverter
U1 Net-_U1-Pad1_ Net-_U1-Pad2_ Net-_U1-Pad3_ Net-_U1-Pad4_ Net-_U1-Pad5_ Net-_U1-Pad6_ Net-_U1-Pad7_ Net-_U1-Pad8_ Net-_U1-Pad9_ Net-_U1-Pad10_ Net-_U1-Pad11_ Net-_U1-Pad12_ Net-_U1-Pad13_ Net-_U1-Pad14_ PORT
U31 Net-_U23-Pad3_ Net-_U1-Pad8_ d_inverter
U30 Net-_U22-Pad3_ Net-_U1-Pad7_ d_inverter
U16 Net-_U16-Pad1_ Net-_U16-Pad2_ d_inverter
U17 Net-_U17-Pad1_ Net-_U17-Pad2_ d_inverter
U22 Net-_U14-Pad2_ Net-_U13-Pad2_ Net-_U22-Pad3_ d_nor
U23 Net-_U15-Pad2_ Net-_U13-Pad2_ Net-_U23-Pad3_ d_nor
U25 Net-_U17-Pad2_ Net-_U13-Pad2_ Net-_U25-Pad3_ d_nor
U24 Net-_U16-Pad2_ Net-_U13-Pad2_ Net-_U24-Pad3_ d_nor
U26 Net-_U18-Pad2_ Net-_U13-Pad2_ Net-_U26-Pad3_ d_nor
U14 Net-_U14-Pad1_ Net-_U14-Pad2_ d_inverter
U15 Net-_U15-Pad1_ Net-_U15-Pad2_ d_inverter
U18 Net-_U18-Pad1_ Net-_U18-Pad2_ d_inverter
U33 Net-_U25-Pad3_ Net-_U1-Pad10_ d_inverter
U34 Net-_U26-Pad3_ Net-_U1-Pad11_ d_inverter
U4 Net-_U1-Pad2_ Net-_U10-Pad1_ d_inverter
U9 Net-_U3-Pad2_ Net-_U10-Pad2_ unconnected-_U9-Pad3_ unconnected-_U9-Pad4_ Net-_U9-Pad5_ Net-_U9-Pad6_ d_dlatch
U3 Net-_U1-Pad1_ Net-_U3-Pad2_ d_inverter
U10 Net-_U10-Pad1_ Net-_U10-Pad2_ unconnected-_U10-Pad3_ unconnected-_U10-Pad4_ Net-_U10-Pad5_ Net-_U10-Pad6_ d_dlatch
U2 Net-_U1-Pad5_ Net-_U2-Pad2_ d_inverter
U7 Net-_U1-Pad6_ Net-_U12-Pad2_ d_inverter
U8 Net-_U2-Pad2_ Net-_U12-Pad1_ d_inverter
U11 Net-_U11-Pad1_ Net-_U10-Pad2_ unconnected-_U11-Pad3_ unconnected-_U11-Pad4_ Net-_U11-Pad5_ Net-_U11-Pad6_ d_dlatch
U5 Net-_U1-Pad3_ Net-_U11-Pad1_ d_inverter
U6 Net-_U1-Pad4_ Net-_U10-Pad2_ d_inverter
U29 Net-_U21-Pad2_ Net-_U13-Pad2_ Net-_U29-Pad3_ d_nor
U28 Net-_U20-Pad2_ Net-_U13-Pad2_ Net-_U28-Pad3_ d_nor
U27 Net-_U19-Pad2_ Net-_U13-Pad2_ Net-_U27-Pad3_ d_nor
U21 Net-_U21-Pad1_ Net-_U21-Pad2_ d_inverter
X8 Net-_U11-Pad5_ Net-_U10-Pad5_ Net-_U9-Pad5_ Net-_U21-Pad1_ 3_and
X7 Net-_U9-Pad6_ Net-_U10-Pad5_ Net-_U11-Pad5_ Net-_U20-Pad1_ 3_and
U20 Net-_U20-Pad1_ Net-_U20-Pad2_ d_inverter
U19 Net-_U19-Pad1_ Net-_U19-Pad2_ d_inverter
U35 Net-_U27-Pad3_ Net-_U1-Pad12_ d_inverter
U36 Net-_U28-Pad3_ Net-_U1-Pad13_ d_inverter
U37 Net-_U29-Pad3_ Net-_U1-Pad14_ d_inverter
X6 Net-_U11-Pad5_ Net-_U10-Pad6_ Net-_U9-Pad5_ Net-_U19-Pad1_ 3_and
X5 Net-_U9-Pad6_ Net-_U10-Pad6_ Net-_U11-Pad5_ Net-_U18-Pad1_ 3_and
U12 Net-_U12-Pad1_ Net-_U12-Pad2_ Net-_U12-Pad3_ d_nor
U13 Net-_U12-Pad3_ Net-_U13-Pad2_ d_inverter
X4 Net-_U11-Pad6_ Net-_U10-Pad5_ Net-_U9-Pad5_ Net-_U17-Pad1_ 3_and
X1 Net-_U9-Pad6_ Net-_U10-Pad6_ Net-_U11-Pad6_ Net-_U14-Pad1_ 3_and
X3 Net-_U9-Pad6_ Net-_U10-Pad5_ Net-_U11-Pad6_ Net-_U16-Pad1_ 3_and
X2 Net-_U11-Pad6_ Net-_U10-Pad6_ Net-_U9-Pad5_ Net-_U15-Pad1_ 3_and
.end
