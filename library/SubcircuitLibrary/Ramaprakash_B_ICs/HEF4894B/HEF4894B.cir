.title KiCad schematic
U20 Net-_U14-Pad5_ Net-_U1-Pad2_ unconnected-_U20-Pad3_ unconnected-_U20-Pad4_ Net-_U20-Pad5_ unconnected-_U20-Pad6_ d_dff
U15 Net-_U14-Pad5_ Net-_U1-Pad3_ unconnected-_U15-Pad3_ unconnected-_U15-Pad4_ Net-_U15-Pad5_ unconnected-_U15-Pad6_ d_dlatch
X5 Net-_U15-Pad5_ Net-_U1-Pad4_ Net-_U18-Pad1_ TRISTATE
U14 Net-_U14-Pad1_ Net-_U1-Pad2_ unconnected-_U14-Pad3_ unconnected-_U14-Pad4_ Net-_U14-Pad5_ unconnected-_U14-Pad6_ d_dff
U21 Net-_U20-Pad5_ Net-_U1-Pad3_ unconnected-_U21-Pad3_ unconnected-_U21-Pad4_ Net-_U21-Pad5_ unconnected-_U21-Pad6_ d_dlatch
U33 Net-_U32-Pad5_ Net-_U1-Pad3_ unconnected-_U33-Pad3_ unconnected-_U33-Pad4_ Net-_U33-Pad5_ unconnected-_U33-Pad6_ d_dlatch
U1 Net-_U1-Pad1_ Net-_U1-Pad2_ Net-_U1-Pad3_ Net-_U1-Pad4_ Net-_U1-Pad5_ Net-_U1-Pad6_ Net-_U1-Pad7_ Net-_U1-Pad8_ Net-_U1-Pad9_ Net-_U1-Pad10_ Net-_U1-Pad11_ Net-_U1-Pad12_ Net-_U1-Pad13_ Net-_U1-Pad14_ Net-_U1-Pad15_ Net-_U1-Pad16_ Net-_U1-Pad17_ Net-_U1-Pad18_ PORT
X9 Net-_U27-Pad5_ Net-_U1-Pad4_ Net-_U30-Pad1_ TRISTATE
U30 Net-_U30-Pad1_ Net-_U1-Pad11_ d_inverter
U8 Net-_U2-Pad5_ Net-_U1-Pad2_ unconnected-_U8-Pad3_ unconnected-_U8-Pad4_ Net-_U14-Pad1_ unconnected-_U8-Pad6_ d_dff
U2 Net-_U1-Pad1_ Net-_U1-Pad2_ unconnected-_U2-Pad3_ unconnected-_U2-Pad4_ Net-_U2-Pad5_ unconnected-_U2-Pad6_ d_dff
U36 Net-_U36-Pad1_ Net-_U1-Pad12_ d_inverter
X11 Net-_U33-Pad5_ Net-_U1-Pad4_ Net-_U36-Pad1_ TRISTATE
U26 Net-_U20-Pad5_ Net-_U1-Pad2_ unconnected-_U26-Pad3_ unconnected-_U26-Pad4_ Net-_U26-Pad5_ unconnected-_U26-Pad6_ d_dff
U32 Net-_U26-Pad5_ Net-_U1-Pad2_ unconnected-_U32-Pad3_ unconnected-_U32-Pad4_ Net-_U32-Pad5_ unconnected-_U32-Pad6_ d_dff
U27 Net-_U26-Pad5_ Net-_U1-Pad3_ unconnected-_U27-Pad3_ unconnected-_U27-Pad4_ Net-_U27-Pad5_ unconnected-_U27-Pad6_ d_dlatch
U9 Net-_U14-Pad1_ Net-_U1-Pad3_ unconnected-_U9-Pad3_ unconnected-_U9-Pad4_ Net-_U9-Pad5_ unconnected-_U9-Pad6_ d_dlatch
U6 Net-_U6-Pad1_ Net-_U1-Pad7_ d_inverter
X1 Net-_U3-Pad5_ Net-_U1-Pad4_ Net-_U6-Pad1_ TRISTATE
U12 Net-_U12-Pad1_ Net-_U1-Pad8_ d_inverter
X3 Net-_U9-Pad5_ Net-_U1-Pad4_ Net-_U12-Pad1_ TRISTATE
X7 Net-_U21-Pad5_ Net-_U1-Pad4_ Net-_U24-Pad1_ TRISTATE
U24 Net-_U24-Pad1_ Net-_U1-Pad10_ d_inverter
U18 Net-_U18-Pad1_ Net-_U1-Pad9_ d_inverter
U3 Net-_U2-Pad5_ Net-_U1-Pad3_ unconnected-_U3-Pad3_ unconnected-_U3-Pad4_ Net-_U3-Pad5_ unconnected-_U3-Pad6_ d_dlatch
U4 Net-_U32-Pad5_ Net-_U1-Pad2_ unconnected-_U4-Pad3_ unconnected-_U4-Pad4_ Net-_U10-Pad1_ unconnected-_U4-Pad6_ d_dff
U11 Net-_U10-Pad5_ Net-_U1-Pad3_ unconnected-_U11-Pad3_ unconnected-_U11-Pad4_ Net-_U11-Pad5_ unconnected-_U11-Pad6_ d_dlatch
U10 Net-_U10-Pad1_ Net-_U1-Pad2_ unconnected-_U10-Pad3_ unconnected-_U10-Pad4_ Net-_U10-Pad5_ unconnected-_U10-Pad6_ d_dff
U5 Net-_U10-Pad1_ Net-_U1-Pad3_ unconnected-_U5-Pad3_ unconnected-_U5-Pad4_ Net-_U5-Pad5_ unconnected-_U5-Pad6_ d_dlatch
U7 Net-_U7-Pad1_ Net-_U1-Pad13_ d_inverter
U13 Net-_U13-Pad1_ Net-_U1-Pad14_ d_inverter
X2 Net-_U5-Pad5_ Net-_U1-Pad4_ Net-_U7-Pad1_ TRISTATE
X4 Net-_U11-Pad5_ Net-_U1-Pad4_ Net-_U13-Pad1_ TRISTATE
U16 Net-_U10-Pad5_ Net-_U1-Pad2_ unconnected-_U16-Pad3_ unconnected-_U16-Pad4_ Net-_U16-Pad5_ unconnected-_U16-Pad6_ d_dff
U23 Net-_U22-Pad5_ Net-_U1-Pad3_ unconnected-_U23-Pad3_ unconnected-_U23-Pad4_ Net-_U23-Pad5_ unconnected-_U23-Pad6_ d_dlatch
U17 Net-_U16-Pad5_ Net-_U1-Pad3_ unconnected-_U17-Pad3_ unconnected-_U17-Pad4_ Net-_U17-Pad5_ unconnected-_U17-Pad6_ d_dlatch
U22 Net-_U16-Pad5_ Net-_U1-Pad2_ unconnected-_U22-Pad3_ unconnected-_U22-Pad4_ Net-_U22-Pad5_ unconnected-_U22-Pad6_ d_dff
U38 Net-_U1-Pad5_ Net-_U1-Pad2_ unconnected-_U38-Pad3_ unconnected-_U38-Pad4_ Net-_U1-Pad6_ unconnected-_U38-Pad6_ d_dlatch
U35 Net-_U1-Pad5_ Net-_U1-Pad3_ unconnected-_U35-Pad3_ unconnected-_U35-Pad4_ Net-_U35-Pad5_ unconnected-_U35-Pad6_ d_dlatch
U34 Net-_U28-Pad5_ Net-_U1-Pad2_ unconnected-_U34-Pad3_ unconnected-_U34-Pad4_ Net-_U1-Pad5_ unconnected-_U34-Pad6_ d_dff
U29 Net-_U28-Pad5_ Net-_U1-Pad3_ unconnected-_U29-Pad3_ unconnected-_U29-Pad4_ Net-_U29-Pad5_ unconnected-_U29-Pad6_ d_dlatch
X12 Net-_U35-Pad5_ Net-_U1-Pad4_ Net-_U37-Pad1_ TRISTATE
U37 Net-_U37-Pad1_ Net-_U1-Pad18_ d_inverter
U31 Net-_U31-Pad1_ Net-_U1-Pad17_ d_inverter
X10 Net-_U29-Pad5_ Net-_U1-Pad4_ Net-_U31-Pad1_ TRISTATE
U28 Net-_U22-Pad5_ Net-_U1-Pad2_ unconnected-_U28-Pad3_ unconnected-_U28-Pad4_ Net-_U28-Pad5_ unconnected-_U28-Pad6_ d_dff
U19 Net-_U19-Pad1_ Net-_U1-Pad15_ d_inverter
U25 Net-_U25-Pad1_ Net-_U1-Pad16_ d_inverter
X6 Net-_U17-Pad5_ Net-_U1-Pad4_ Net-_U19-Pad1_ TRISTATE
X8 Net-_U23-Pad5_ Net-_U1-Pad4_ Net-_U25-Pad1_ TRISTATE
.end
