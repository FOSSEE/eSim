.title KiCad schematic
U1 Net-_U1-Pad1_ Net-_U1-Pad2_ Net-_U1-Pad3_ Net-_U1-Pad4_ Net-_U1-Pad5_ Net-_U1-Pad6_ Net-_U1-Pad7_ Net-_U1-Pad8_ Net-_U1-Pad9_ Net-_U1-Pad10_ Net-_U1-Pad11_ Net-_U1-Pad12_ PORT
U23 Net-_U19-Pad3_ Net-_U1-Pad10_ d_inverter
U22 Net-_U18-Pad3_ Net-_U1-Pad9_ d_inverter
X2 Net-_U1-Pad2_ Net-_U3-Pad1_ 74HC14
X1 Net-_U1-Pad1_ Net-_U2-Pad1_ 74HC14
U18 Net-_U10-Pad2_ Net-_U14-Pad2_ Net-_U18-Pad3_ d_and
X3 Net-_U1-Pad3_ Net-_U4-Pad1_ 74HC14
X4 Net-_U1-Pad4_ Net-_U5-Pad1_ 74HC14
U19 Net-_U11-Pad2_ Net-_U15-Pad2_ Net-_U19-Pad3_ d_and
U4 Net-_U4-Pad1_ Net-_U11-Pad1_ adc_bridge_1
U5 Net-_U5-Pad1_ Net-_U15-Pad1_ adc_bridge_1
U11 Net-_U11-Pad1_ Net-_U11-Pad2_ d_inverter
U15 Net-_U15-Pad1_ Net-_U15-Pad2_ d_inverter
U3 Net-_U3-Pad1_ Net-_U14-Pad1_ adc_bridge_1
U14 Net-_U14-Pad1_ Net-_U14-Pad2_ d_inverter
U10 Net-_U10-Pad1_ Net-_U10-Pad2_ d_inverter
U2 Net-_U2-Pad1_ Net-_U10-Pad1_ adc_bridge_1
U12 Net-_U12-Pad1_ Net-_U12-Pad2_ d_inverter
U16 Net-_U16-Pad1_ Net-_U16-Pad2_ d_inverter
X7 Net-_U1-Pad7_ Net-_U8-Pad1_ 74HC14
X8 Net-_U1-Pad8_ Net-_U9-Pad1_ 74HC14
U7 Net-_U7-Pad1_ Net-_U16-Pad1_ adc_bridge_1
U6 Net-_U6-Pad1_ Net-_U12-Pad1_ adc_bridge_1
X5 Net-_U1-Pad5_ Net-_U6-Pad1_ 74HC14
X6 Net-_U1-Pad6_ Net-_U7-Pad1_ 74HC14
U25 Net-_U21-Pad3_ Net-_U1-Pad12_ d_inverter
U21 Net-_U13-Pad2_ Net-_U17-Pad2_ Net-_U21-Pad3_ d_and
U20 Net-_U12-Pad2_ Net-_U16-Pad2_ Net-_U20-Pad3_ d_and
U24 Net-_U20-Pad3_ Net-_U1-Pad11_ d_inverter
U17 Net-_U17-Pad1_ Net-_U17-Pad2_ d_inverter
U9 Net-_U9-Pad1_ Net-_U17-Pad1_ adc_bridge_1
U8 Net-_U8-Pad1_ Net-_U13-Pad1_ adc_bridge_1
U13 Net-_U13-Pad1_ Net-_U13-Pad2_ d_inverter
.end
