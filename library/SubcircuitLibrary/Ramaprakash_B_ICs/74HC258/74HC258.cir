.title KiCad schematic
U13 Net-_U1-Pad2_ Net-_U13-Pad2_ d_buffer
U1 Net-_U1-Pad1_ Net-_U1-Pad2_ Net-_U1-Pad3_ Net-_U1-Pad4_ Net-_U1-Pad5_ Net-_U1-Pad6_ Net-_U1-Pad7_ Net-_U1-Pad8_ Net-_U1-Pad9_ Net-_U1-Pad10_ Net-_U1-Pad11_ Net-_U1-Pad12_ Net-_U1-Pad13_ Net-_U1-Pad14_ PORT
U12 Net-_U1-Pad1_ Net-_U12-Pad2_ d_buffer
U22 Net-_U12-Pad2_ Net-_U11-Pad2_ Net-_U22-Pad3_ d_and
U24 Net-_U14-Pad2_ Net-_U11-Pad2_ Net-_U24-Pad3_ d_and
U23 Net-_U13-Pad2_ Net-_U21-Pad2_ Net-_U23-Pad3_ d_and
U15 Net-_U1-Pad4_ Net-_U15-Pad2_ d_buffer
U14 Net-_U1-Pad3_ Net-_U14-Pad2_ d_buffer
U25 Net-_U15-Pad2_ Net-_U21-Pad2_ Net-_U25-Pad3_ d_and
U26 Net-_U16-Pad2_ Net-_U11-Pad2_ Net-_U26-Pad3_ d_and
X1 Net-_U30-Pad3_ Net-_U20-Pad2_ Net-_U1-Pad11_ TRISTATE
U30 Net-_U22-Pad3_ Net-_U23-Pad3_ Net-_U30-Pad3_ d_nor
U31 Net-_U24-Pad3_ Net-_U25-Pad3_ Net-_U31-Pad3_ d_nor
X4 Net-_U33-Pad3_ Net-_U20-Pad2_ Net-_U1-Pad14_ TRISTATE
X3 Net-_U32-Pad3_ Net-_U20-Pad2_ Net-_U1-Pad13_ TRISTATE
X2 Net-_U31-Pad3_ Net-_U20-Pad2_ Net-_U1-Pad12_ TRISTATE
U27 Net-_U17-Pad2_ Net-_U21-Pad2_ Net-_U27-Pad3_ d_and
U28 Net-_U18-Pad2_ Net-_U11-Pad2_ Net-_U28-Pad3_ d_and
U32 Net-_U26-Pad3_ Net-_U27-Pad3_ Net-_U32-Pad3_ d_nor
U29 Net-_U19-Pad2_ Net-_U21-Pad2_ Net-_U29-Pad3_ d_and
U33 Net-_U28-Pad3_ Net-_U29-Pad3_ Net-_U33-Pad3_ d_nor
U21 Net-_U11-Pad2_ Net-_U21-Pad2_ d_inverter
U11 Net-_U1-Pad10_ Net-_U11-Pad2_ d_inverter
U19 Net-_U1-Pad8_ Net-_U19-Pad2_ d_buffer
U20 Net-_U1-Pad9_ Net-_U20-Pad2_ d_buffer
U17 Net-_U1-Pad6_ Net-_U17-Pad2_ d_buffer
U16 Net-_U1-Pad5_ Net-_U16-Pad2_ d_buffer
U18 Net-_U1-Pad7_ Net-_U18-Pad2_ d_buffer
.end
