.title KiCad schematic
X1 Net-_U3-Pad2_ Net-_U13-Pad2_ Net-_U11-Pad2_ Net-_U4-Pad2_ 3_and
U4 Net-_U4-Pad1_ Net-_U4-Pad2_ Net-_U4-Pad3_ d_or
X2 Net-_U5-Pad2_ Net-_U13-Pad2_ Net-_U10-Pad2_ Net-_U4-Pad1_ 3_and
X4 Net-_U7-Pad2_ Net-_U12-Pad2_ Net-_U11-Pad2_ Net-_U8-Pad2_ 3_and
X5 Net-_U9-Pad2_ Net-_U12-Pad2_ Net-_U10-Pad2_ Net-_U8-Pad1_ 3_and
X3 Net-_U6-Pad3_ Net-_U2-Pad2_ Net-_U1-Pad13_ TRISTATE
U8 Net-_U8-Pad1_ Net-_U8-Pad2_ Net-_U6-Pad1_ d_or
U6 Net-_U6-Pad1_ Net-_U4-Pad3_ Net-_U6-Pad3_ d_or
U1 Net-_U1-Pad1_ Net-_U1-Pad2_ Net-_U1-Pad3_ Net-_U1-Pad4_ Net-_U1-Pad5_ Net-_U1-Pad6_ Net-_U1-Pad7_ Net-_U1-Pad8_ Net-_U1-Pad9_ Net-_U1-Pad10_ Net-_U1-Pad11_ Net-_U1-Pad12_ Net-_U1-Pad13_ Net-_U1-Pad14_ PORT
X6 Net-_U11-Pad2_ Net-_U13-Pad2_ Net-_U14-Pad2_ Net-_U15-Pad2_ 3_and
X9 Net-_U11-Pad2_ Net-_U12-Pad2_ Net-_U18-Pad2_ Net-_U19-Pad2_ 3_and
X7 Net-_U10-Pad2_ Net-_U13-Pad2_ Net-_U16-Pad2_ Net-_U15-Pad1_ 3_and
X8 Net-_U17-Pad3_ Net-_U21-Pad2_ Net-_U1-Pad14_ TRISTATE
U17 Net-_U17-Pad1_ Net-_U15-Pad3_ Net-_U17-Pad3_ d_or
U15 Net-_U15-Pad1_ Net-_U15-Pad2_ Net-_U15-Pad3_ d_or
X10 Net-_U10-Pad2_ Net-_U12-Pad2_ Net-_U20-Pad2_ Net-_U19-Pad1_ 3_and
U19 Net-_U19-Pad1_ Net-_U19-Pad2_ Net-_U17-Pad1_ d_or
U16 Net-_U1-Pad9_ Net-_U16-Pad2_ d_buffer
U14 Net-_U1-Pad8_ Net-_U14-Pad2_ d_buffer
U18 Net-_U1-Pad10_ Net-_U18-Pad2_ d_buffer
U20 Net-_U1-Pad11_ Net-_U20-Pad2_ d_buffer
U21 Net-_U1-Pad12_ Net-_U21-Pad2_ d_inverter
U11 Net-_U10-Pad2_ Net-_U11-Pad2_ d_inverter
U10 Net-_U1-Pad6_ Net-_U10-Pad2_ d_inverter
U12 Net-_U1-Pad7_ Net-_U12-Pad2_ d_inverter
U13 Net-_U12-Pad2_ Net-_U13-Pad2_ d_inverter
U3 Net-_U1-Pad2_ Net-_U3-Pad2_ d_buffer
U5 Net-_U1-Pad3_ Net-_U5-Pad2_ d_buffer
U2 Net-_U1-Pad1_ Net-_U2-Pad2_ d_inverter
U9 Net-_U1-Pad5_ Net-_U9-Pad2_ d_buffer
U7 Net-_U1-Pad4_ Net-_U7-Pad2_ d_buffer
.end
