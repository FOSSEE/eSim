.title KiCad schematic
U7 Net-_U6-Pad2_ Net-_U7-Pad2_ d_inverter
U8 Net-_U7-Pad2_ Net-_U1-Pad4_ d_inverter
U1 Net-_U1-Pad1_ Net-_U1-Pad1_ Net-_U1-Pad3_ Net-_U1-Pad4_ PORT
U6 Net-_U5-Pad2_ Net-_U6-Pad2_ d_inverter
U3 Net-_U1-Pad3_ Net-_U1-Pad4_ Net-_U3-Pad3_ d_and
U4 Net-_U3-Pad3_ Net-_U4-Pad2_ d_inverter
U5 Net-_U4-Pad2_ Net-_U5-Pad2_ d_inverter
U2 Net-_U1-Pad1_ Net-_U1-Pad4_ Net-_U1-Pad3_ d_xor
.end
