.title KiCad schematic
v3 A3 GND pulse
v7 B3 GND pulse
v4 A4 GND pulse
v8 B4 GND pulse
U6 B2 Net-_U6-Pad2_ adc_bridge_1
U7 B3 Net-_U7-Pad2_ adc_bridge_1
U3 A3 Net-_U3-Pad2_ adc_bridge_1
U4 A4 Net-_U4-Pad2_ adc_bridge_1
U8 B4 Net-_U8-Pad2_ adc_bridge_1
v6 B2 GND pulse
v2 A2 GND pulse
U2 A2 Net-_U2-Pad2_ adc_bridge_1
U1 A1 Net-_U1-Pad2_ adc_bridge_1
v1 A1 GND pulse
v5 B1 GND pulse
X1 Net-_U1-Pad2_ Net-_U5-Pad2_ Net-_U2-Pad2_ Net-_U6-Pad2_ Net-_U3-Pad2_ Net-_U7-Pad2_ Net-_U4-Pad2_ Net-_U8-Pad2_ Net-_U9-Pad1_ Net-_U10-Pad1_ Net-_U11-Pad1_ Net-_U12-Pad1_ SN74386
U5 B1 Net-_U5-Pad2_ adc_bridge_1
R1 Y1 VCC 1k
U10 Net-_U10-Pad1_ Y2 dac_bridge_1
U9 Net-_U9-Pad1_ Y1 dac_bridge_1
U12 Net-_U12-Pad1_ Y4 dac_bridge_1
U11 Net-_U11-Pad1_ Y3 dac_bridge_1
R3 Y3 VCC 1k
R2 Y2 VCC 1k
R4 Y4 VCC 1k
.end
