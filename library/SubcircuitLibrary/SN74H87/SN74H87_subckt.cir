.title KiCad schematic
U21 Net-_U15-Pad3_ Net-_U16-Pad3_ Net-_U21-Pad3_ d_or
U20 Net-_U12-Pad3_ Net-_U13-Pad3_ Net-_U20-Pad3_ d_or
U12 S0 A3 Net-_U12-Pad3_ d_and
U13 S1 Net-_U13-Pad2_ Net-_U13-Pad3_ d_and
U14 S0 S1 Net-_U14-Pad3_ d_and
U24 Net-_U20-Pad3_ Net-_U14-Pad3_ Y3 d_or
U1 S0 S1 A1 A2 A3 A4 Y1 Y2 Y3 Y4 PORT
U16 S1 Net-_U16-Pad2_ Net-_U16-Pad3_ d_and
U17 S0 S1 Net-_U17-Pad3_ d_and
U15 S0 A4 Net-_U15-Pad3_ d_and
U25 Net-_U21-Pad3_ Net-_U17-Pad3_ Y4 d_or
U2 A1 Net-_U2-Pad2_ d_inverter
U3 A2 Net-_U10-Pad2_ d_inverter
U5 A4 Net-_U16-Pad2_ d_inverter
U4 A3 Net-_U13-Pad2_ d_inverter
U19 Net-_U19-Pad1_ Net-_U10-Pad3_ Net-_U19-Pad3_ d_or
U23 Net-_U19-Pad3_ Net-_U11-Pad3_ Y2 d_or
U7 S1 Net-_U2-Pad2_ Net-_U18-Pad2_ d_and
U8 S0 S1 Net-_U22-Pad2_ d_and
U6 S0 A1 Net-_U18-Pad1_ d_and
U18 Net-_U18-Pad1_ Net-_U18-Pad2_ Net-_U18-Pad3_ d_or
U22 Net-_U18-Pad3_ Net-_U22-Pad2_ Y1 d_or
U11 S0 S1 Net-_U11-Pad3_ d_and
U10 S1 Net-_U10-Pad2_ Net-_U10-Pad3_ d_and
U9 S0 A2 Net-_U19-Pad1_ d_and
.end
