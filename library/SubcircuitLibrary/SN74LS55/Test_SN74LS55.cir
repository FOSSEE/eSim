.title KiCad schematic
U1 A Net-_U1-Pad2_ adc_bridge_1
U3 C Net-_U3-Pad2_ adc_bridge_1
U2 B Net-_U2-Pad2_ adc_bridge_1
v3 C GND pulse
v4 D GND pulse
v1 A GND pulse
v2 B GND pulse
X1 Net-_U1-Pad2_ Net-_U2-Pad2_ Net-_U3-Pad2_ Net-_U4-Pad2_ Net-_U5-Pad2_ Net-_U6-Pad2_ Net-_U7-Pad2_ Net-_U8-Pad2_ Net-_U9-Pad1_ SN74LS55
U9 Net-_U9-Pad1_ Y dac_bridge_1
v8 H GND pulse
U8 H Net-_U8-Pad2_ adc_bridge_1
U7 G Net-_U7-Pad2_ adc_bridge_1
v7 G GND pulse
v6 F GND pulse
v5 E GND pulse
U4 D Net-_U4-Pad2_ adc_bridge_1
U5 E Net-_U5-Pad2_ adc_bridge_1
U6 F Net-_U6-Pad2_ adc_bridge_1
.end
