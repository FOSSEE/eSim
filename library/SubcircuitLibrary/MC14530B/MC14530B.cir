.title KiCad schematic
U25 Net-_U25-Pad1_ /E1 Net-_U25-Pad3_ d_and
U24 Net-_U13-Pad1_ /E1 Net-_U24-Pad3_ d_and
U22 Net-_U22-Pad1_ /E1 Net-_U22-Pad3_ d_and
U23 Net-_U23-Pad1_ Net-_U23-Pad2_ Net-_U23-Pad3_ d_or
U26 Net-_U10-Pad3_ /E1 Net-_U26-Pad3_ d_and
U28 Net-_U10-Pad3_ /D1 Net-_U28-Pad3_ d_and
U27 Net-_U11-Pad3_ /E1 Net-_U27-Pad3_ d_and
U30 Net-_U15-Pad1_ /E2 Net-_U30-Pad3_ d_and
U31 Net-_U14-Pad3_ /E2 Net-_U31-Pad3_ d_and
U29 Net-_U12-Pad3_ Net-_U13-Pad3_ Net-_U29-Pad3_ d_or
U32 Net-_U16-Pad3_ /D2 Net-_U32-Pad3_ d_and
U8 Net-_U12-Pad1_ /C1 Net-_U23-Pad1_ d_and
U9 /C1 /D1 Net-_U25-Pad1_ d_and
U11 /B1 /D1 Net-_U11-Pad3_ d_and
U10 /B1 /C1 Net-_U10-Pad3_ d_and
U7 Net-_U12-Pad1_ /D1 Net-_U23-Pad2_ d_and
U6 /A1 /D1 Net-_U22-Pad1_ d_and
U12 Net-_U12-Pad1_ /E1 Net-_U12-Pad3_ d_and
U13 Net-_U13-Pad1_ /D1 Net-_U13-Pad3_ d_and
U14 /A2 /D2 Net-_U14-Pad3_ d_and
U15 Net-_U15-Pad1_ /D2 Net-_U15-Pad3_ d_and
U16 /B2 /C2 Net-_U16-Pad3_ d_and
U4 /A2 /C2 Net-_U15-Pad1_ d_and
U5 /A2 /B2 Net-_U17-Pad1_ d_and
U2 /A1 /B1 Net-_U12-Pad1_ d_and
U3 /A1 /C1 Net-_U13-Pad1_ d_and
U37 Net-_U21-Pad3_ Net-_U15-Pad3_ Net-_U37-Pad3_ d_or
U35 Net-_U19-Pad3_ /E2 Net-_U35-Pad3_ d_and
U36 Net-_U20-Pad3_ /E2 Net-_U36-Pad3_ d_and
U33 Net-_U16-Pad3_ /E2 Net-_U33-Pad3_ d_and
U34 Net-_U17-Pad3_ Net-_U18-Pad3_ Net-_U34-Pad3_ d_or
U43 Net-_U32-Pad3_ Net-_U33-Pad3_ Net-_U43-Pad3_ d_or
U42 Net-_U30-Pad3_ Net-_U31-Pad3_ Net-_U42-Pad3_ d_or
U39 Net-_U28-Pad3_ Net-_U26-Pad3_ Net-_U39-Pad3_ d_or
U38 Net-_U24-Pad3_ Net-_U22-Pad3_ Net-_U38-Pad3_ d_or
U41 Net-_U23-Pad3_ Net-_U29-Pad3_ Net-_U41-Pad3_ d_or
U40 Net-_U27-Pad3_ Net-_U25-Pad3_ Net-_U40-Pad3_ d_or
U45 Net-_U34-Pad3_ Net-_U37-Pad3_ Net-_U45-Pad3_ d_or
U44 Net-_U35-Pad3_ Net-_U36-Pad3_ Net-_U44-Pad3_ d_or
U49 Net-_U44-Pad3_ Net-_U45-Pad3_ Net-_U49-Pad3_ d_or
U48 Net-_U42-Pad3_ Net-_U43-Pad3_ Net-_U48-Pad3_ d_or
U46 Net-_U38-Pad3_ Net-_U39-Pad3_ Net-_U46-Pad3_ d_or
U47 Net-_U40-Pad3_ Net-_U41-Pad3_ Net-_U47-Pad3_ d_or
U51 Net-_U48-Pad3_ Net-_U49-Pad3_ Net-_U1-Pad12_ d_or
U1 /A1 /A2 /B1 /B2 /C1 /C2 /D1 /D2 /E1 /E2 Net-_U1-Pad11_ Net-_U1-Pad12_ PORT
U50 Net-_U46-Pad3_ Net-_U47-Pad3_ Net-_U1-Pad11_ d_or
U17 Net-_U17-Pad1_ /C2 Net-_U17-Pad3_ d_and
U18 Net-_U17-Pad1_ /D2 Net-_U18-Pad3_ d_and
U20 /C2 /D2 Net-_U20-Pad3_ d_and
U19 /B2 /D2 Net-_U19-Pad3_ d_and
U21 Net-_U17-Pad1_ /E2 Net-_U21-Pad3_ d_and
.end
