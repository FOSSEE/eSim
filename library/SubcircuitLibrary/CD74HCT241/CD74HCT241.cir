.title KiCad schematic
U1 Net-_U1-Pad1_ Net-_U1-Pad2_ Net-_U1-Pad3_ Net-_U1-Pad4_ Net-_U1-Pad5_ Net-_U1-Pad6_ Net-_U1-Pad7_ Net-_U1-Pad8_ Net-_U1-Pad9_ Net-_U1-Pad11_ Net-_U1-Pad12_ Net-_U1-Pad13_ Net-_U1-Pad14_ Net-_U1-Pad15_ Net-_U1-Pad16_ Net-_U1-Pad17_ Net-_U1-Pad18_ Net-_U1-Pad19_ PORT
U11 Net-_U1-Pad17_ Net-_U11-Pad2_ d_buffer
U9 Net-_U1-Pad13_ Net-_U17-Pad1_ d_buffer
U10 Net-_U1-Pad15_ Net-_U10-Pad2_ d_buffer
U3 Net-_U1-Pad11_ Net-_U16-Pad1_ d_buffer
U7 Net-_U1-Pad8_ Net-_U15-Pad1_ d_buffer
U8 Net-_U1-Pad19_ Net-_U16-Pad2_ d_buffer
U5 Net-_U1-Pad2_ Net-_U12-Pad1_ d_buffer
U2 Net-_U1-Pad1_ Net-_U12-Pad2_ d_inverter
U14 Net-_U14-Pad1_ Net-_U12-Pad2_ Net-_U1-Pad14_ d_tristate
U13 Net-_U13-Pad1_ Net-_U12-Pad2_ Net-_U1-Pad16_ d_tristate
U6 Net-_U1-Pad4_ Net-_U13-Pad1_ d_buffer
U4 Net-_U1-Pad6_ Net-_U14-Pad1_ d_buffer
U12 Net-_U12-Pad1_ Net-_U12-Pad2_ Net-_U1-Pad18_ d_tristate
U15 Net-_U15-Pad1_ Net-_U12-Pad2_ Net-_U1-Pad12_ d_tristate
U18 Net-_U10-Pad2_ Net-_U16-Pad2_ Net-_U1-Pad5_ d_tristate
U19 Net-_U11-Pad2_ Net-_U16-Pad2_ Net-_U1-Pad3_ d_tristate
U17 Net-_U17-Pad1_ Net-_U16-Pad2_ Net-_U1-Pad7_ d_tristate
U16 Net-_U16-Pad1_ Net-_U16-Pad2_ Net-_U1-Pad9_ d_tristate
.end
