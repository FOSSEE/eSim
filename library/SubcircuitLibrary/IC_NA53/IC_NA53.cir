.title KiCad schematic
U6 Net-_U5-Pad3_ Net-_U1-Pad6_ d_inverter
U5 Net-_U4-Pad3_ Net-_U1-Pad5_ Net-_U5-Pad3_ d_and
U1 Net-_U1-Pad1_ Net-_U1-Pad2_ Net-_U1-Pad3_ Net-_U1-Pad4_ Net-_U1-Pad5_ Net-_U1-Pad6_ PORT
U2 Net-_U1-Pad1_ Net-_U1-Pad2_ Net-_U2-Pad3_ d_and
U3 Net-_U2-Pad3_ Net-_U1-Pad3_ Net-_U3-Pad3_ d_and
U4 Net-_U3-Pad3_ Net-_U1-Pad4_ Net-_U4-Pad3_ d_and
.end
