.title KiCad schematic
U15 Net-_U15-Pad1_ Net-_U13-Pad2_ Net-_U15-Pad3_ d_and
X10 Net-_U29-Pad2_ Net-_U13-Pad1_ Net-_U13-Pad2_ Net-_U1-Pad2_ Net-_U30-Pad2_ 4_and
X4 Net-_U4-Pad2_ Net-_U1-Pad2_ Net-_U59-Pad5_ Net-_U23-Pad2_ 3_and
X11 Net-_U30-Pad2_ Net-_U14-Pad1_ Net-_U13-Pad2_ Net-_U1-Pad2_ Net-_U31-Pad2_ 4_and
U16 Net-_U16-Pad1_ Net-_U13-Pad2_ Net-_U16-Pad3_ d_and
U22 Net-_U14-Pad3_ Net-_U22-Pad2_ Net-_U22-Pad3_ d_or
X3 Net-_U4-Pad2_ Net-_U1-Pad2_ Net-_U59-Pad4_ Net-_U22-Pad2_ 3_and
X2 Net-_U45-Pad2_ Net-_U13-Pad2_ Net-_U1-Pad2_ Net-_U29-Pad2_ 3_and
U14 Net-_U14-Pad1_ Net-_U13-Pad2_ Net-_U14-Pad3_ d_and
U23 Net-_U15-Pad3_ Net-_U23-Pad2_ Net-_U23-Pad3_ d_or
U30 Net-_U22-Pad3_ Net-_U30-Pad2_ Net-_U30-Pad3_ d_xor
U31 Net-_U23-Pad3_ Net-_U31-Pad2_ Net-_U31-Pad3_ d_xor
U32 Net-_U24-Pad3_ Net-_U32-Pad2_ Net-_U32-Pad3_ d_xor
U24 Net-_U16-Pad3_ Net-_U24-Pad2_ Net-_U24-Pad3_ d_or
X6 Net-_U4-Pad2_ Net-_U1-Pad2_ Net-_U59-Pad7_ Net-_U25-Pad2_ 3_and
X13 Net-_U32-Pad2_ Net-_U16-Pad1_ Net-_U13-Pad2_ Net-_U1-Pad2_ Net-_U33-Pad2_ 4_and
U59 Net-_U2-Pad1_ Net-_U3-Pad1_ Net-_U59-Pad3_ Net-_U59-Pad4_ Net-_U59-Pad5_ Net-_U59-Pad6_ Net-_U59-Pad7_ Net-_U59-Pad8_ Net-_U59-Pad9_ Net-_U59-Pad10_ Net-_U1-Pad1_ Net-_U58-Pad1_ Net-_U57-Pad2_ Net-_U55-Pad3_ Net-_U54-Pad3_ Net-_U53-Pad3_ Net-_U52-Pad3_ Net-_U51-Pad3_ Net-_U50-Pad3_ Net-_U49-Pad3_ Net-_U48-Pad3_ Net-_U56-Pad1_ PORT
U8 Net-_U16-Pad1_ Net-_U7-Pad3_ Net-_U8-Pad3_ d_and
U33 Net-_U25-Pad3_ Net-_U33-Pad2_ Net-_U33-Pad3_ d_xor
X12 Net-_U31-Pad2_ Net-_U15-Pad1_ Net-_U13-Pad2_ Net-_U1-Pad2_ Net-_U32-Pad2_ 4_and
U17 Net-_U17-Pad1_ Net-_U13-Pad2_ Net-_U17-Pad3_ d_and
U25 Net-_U17-Pad3_ Net-_U25-Pad2_ Net-_U25-Pad3_ d_or
X5 Net-_U4-Pad2_ Net-_U1-Pad2_ Net-_U59-Pad6_ Net-_U24-Pad2_ 3_and
U13 Net-_U13-Pad1_ Net-_U13-Pad2_ Net-_U13-Pad3_ d_and
U29 Net-_U21-Pad3_ Net-_U29-Pad2_ Net-_U29-Pad3_ d_xor
U21 Net-_U13-Pad3_ Net-_U21-Pad2_ Net-_U21-Pad3_ d_or
X1 Net-_U4-Pad2_ Net-_U1-Pad2_ Net-_U59-Pad3_ Net-_U21-Pad2_ 3_and
U4 Net-_U13-Pad2_ Net-_U4-Pad2_ d_inverter
U5 Net-_U13-Pad1_ Net-_U45-Pad2_ Net-_U5-Pad3_ d_and
U3 Net-_U3-Pad1_ Net-_U13-Pad2_ d_buffer
U2 Net-_U2-Pad1_ Net-_U2-Pad2_ d_buffer
U7 Net-_U15-Pad1_ Net-_U6-Pad3_ Net-_U7-Pad3_ d_and
U6 Net-_U14-Pad1_ Net-_U5-Pad3_ Net-_U6-Pad3_ d_and
U18 Net-_U10-Pad1_ Net-_U13-Pad2_ Net-_U18-Pad3_ d_and
U41 Net-_U33-Pad3_ Net-_U2-Pad2_ unconnected-_U41-Pad3_ unconnected-_U41-Pad4_ Net-_U17-Pad1_ unconnected-_U41-Pad6_ d_dff
U26 Net-_U18-Pad3_ Net-_U26-Pad2_ Net-_U26-Pad3_ d_or
U34 Net-_U26-Pad3_ Net-_U34-Pad2_ Net-_U34-Pad3_ d_xor
U10 Net-_U10-Pad1_ Net-_U10-Pad2_ Net-_U10-Pad3_ d_and
U9 Net-_U17-Pad1_ Net-_U8-Pad3_ Net-_U10-Pad2_ d_and
X9 Net-_U4-Pad2_ Net-_U1-Pad2_ Net-_U59-Pad10_ Net-_U28-Pad2_ 3_and
U20 Net-_U12-Pad1_ Net-_U13-Pad2_ Net-_U20-Pad3_ d_and
X16 Net-_U35-Pad2_ Net-_U11-Pad1_ Net-_U13-Pad2_ Net-_U1-Pad2_ Net-_U36-Pad2_ 4_and
U36 Net-_U28-Pad3_ Net-_U36-Pad2_ Net-_U36-Pad3_ d_xor
U35 Net-_U27-Pad3_ Net-_U35-Pad2_ Net-_U35-Pad3_ d_xor
U43 Net-_U35-Pad3_ Net-_U2-Pad2_ unconnected-_U43-Pad3_ unconnected-_U43-Pad4_ Net-_U11-Pad1_ unconnected-_U43-Pad6_ d_dff
U28 Net-_U20-Pad3_ Net-_U28-Pad2_ Net-_U28-Pad3_ d_or
U44 Net-_U36-Pad3_ Net-_U2-Pad2_ unconnected-_U44-Pad3_ unconnected-_U44-Pad4_ Net-_U12-Pad1_ unconnected-_U44-Pad6_ d_dff
X7 Net-_U4-Pad2_ Net-_U1-Pad2_ Net-_U59-Pad8_ Net-_U26-Pad2_ 3_and
X14 Net-_U33-Pad2_ Net-_U17-Pad1_ Net-_U13-Pad2_ Net-_U1-Pad2_ Net-_U34-Pad2_ 4_and
U27 Net-_U19-Pad3_ Net-_U27-Pad2_ Net-_U27-Pad3_ d_or
X15 Net-_U34-Pad2_ Net-_U10-Pad1_ Net-_U13-Pad2_ Net-_U1-Pad2_ Net-_U35-Pad2_ 4_and
X8 Net-_U4-Pad2_ Net-_U1-Pad2_ Net-_U59-Pad9_ Net-_U27-Pad2_ 3_and
U19 Net-_U11-Pad1_ Net-_U13-Pad2_ Net-_U19-Pad3_ d_and
U12 Net-_U12-Pad1_ Net-_U11-Pad3_ Net-_U12-Pad3_ d_and
U11 Net-_U11-Pad1_ Net-_U10-Pad3_ Net-_U11-Pad3_ d_and
U1 Net-_U1-Pad1_ Net-_U1-Pad2_ d_buffer
U55 Net-_U12-Pad1_ Net-_U47-Pad2_ Net-_U55-Pad3_ d_tristate
U42 Net-_U34-Pad3_ Net-_U2-Pad2_ unconnected-_U42-Pad3_ unconnected-_U42-Pad4_ Net-_U10-Pad1_ unconnected-_U42-Pad6_ d_dff
U54 Net-_U11-Pad1_ Net-_U47-Pad2_ Net-_U54-Pad3_ d_tristate
U57 Net-_U46-Pad2_ Net-_U57-Pad2_ d_inverter
U58 Net-_U58-Pad1_ Net-_U47-Pad1_ d_inverter
U47 Net-_U47-Pad1_ Net-_U47-Pad2_ d_buffer
U46 Net-_U12-Pad3_ Net-_U46-Pad2_ d_buffer
U53 Net-_U10-Pad1_ Net-_U47-Pad2_ Net-_U53-Pad3_ d_tristate
U49 Net-_U14-Pad1_ Net-_U47-Pad2_ Net-_U49-Pad3_ d_tristate
U50 Net-_U15-Pad1_ Net-_U47-Pad2_ Net-_U50-Pad3_ d_tristate
U48 Net-_U13-Pad1_ Net-_U47-Pad2_ Net-_U48-Pad3_ d_tristate
U56 Net-_U56-Pad1_ Net-_U45-Pad1_ d_buffer
U38 Net-_U30-Pad3_ Net-_U2-Pad2_ unconnected-_U38-Pad3_ unconnected-_U38-Pad4_ Net-_U14-Pad1_ unconnected-_U38-Pad6_ d_dff
U37 Net-_U29-Pad3_ Net-_U2-Pad2_ unconnected-_U37-Pad3_ unconnected-_U37-Pad4_ Net-_U13-Pad1_ unconnected-_U37-Pad6_ d_dff
U45 Net-_U45-Pad1_ Net-_U45-Pad2_ d_inverter
U40 Net-_U32-Pad3_ Net-_U2-Pad2_ unconnected-_U40-Pad3_ unconnected-_U40-Pad4_ Net-_U16-Pad1_ unconnected-_U40-Pad6_ d_dff
U52 Net-_U17-Pad1_ Net-_U47-Pad2_ Net-_U52-Pad3_ d_tristate
U51 Net-_U16-Pad1_ Net-_U47-Pad2_ Net-_U51-Pad3_ d_tristate
U39 Net-_U31-Pad3_ Net-_U2-Pad2_ unconnected-_U39-Pad3_ unconnected-_U39-Pad4_ Net-_U15-Pad1_ unconnected-_U39-Pad6_ d_dff
.end
