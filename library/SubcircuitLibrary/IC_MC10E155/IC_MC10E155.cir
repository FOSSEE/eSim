.title KiCad schematic
U27 Net-_U19-Pad3_ Net-_U20-Pad3_ Net-_U27-Pad3_ d_or
U33 Net-_U27-Pad3_ Net-_U29-Pad2_ unconnected-_U33-Pad3_ Net-_U29-Pad4_ Net-_U1-Pad18_ unconnected-_U33-Pad6_ d_dlatch
U32 Net-_U26-Pad3_ Net-_U29-Pad2_ unconnected-_U32-Pad3_ Net-_U29-Pad4_ Net-_U1-Pad19_ unconnected-_U32-Pad6_ d_dlatch
U1 Net-_U1-Pad1_ Net-_U1-Pad2_ Net-_U1-Pad3_ Net-_U1-Pad4_ Net-_U1-Pad5_ Net-_U1-Pad6_ Net-_U1-Pad7_ Net-_U1-Pad8_ Net-_U1-Pad9_ Net-_U1-Pad10_ Net-_U1-Pad11_ Net-_U1-Pad12_ Net-_U1-Pad13_ Net-_U1-Pad14_ Net-_U1-Pad15_ Net-_U1-Pad16_ Net-_U1-Pad17_ Net-_U1-Pad18_ Net-_U1-Pad19_ Net-_U1-Pad20_ Net-_U1-Pad21_ Net-_U1-Pad22_ PORT
U26 Net-_U17-Pad3_ Net-_U18-Pad3_ Net-_U26-Pad3_ d_or
U18 Net-_U1-Pad8_ Net-_U10-Pad1_ Net-_U18-Pad3_ d_and
U20 Net-_U1-Pad10_ Net-_U10-Pad1_ Net-_U20-Pad3_ d_and
U19 Net-_U1-Pad9_ Net-_U19-Pad2_ Net-_U19-Pad3_ d_and
U8 Net-_U10-Pad1_ Net-_U17-Pad2_ d_inverter
U10 Net-_U10-Pad1_ Net-_U10-Pad2_ d_inverter
U4 Net-_U1-Pad14_ Net-_U29-Pad4_ d_buffer
U3 Net-_U1-Pad15_ Net-_U1-Pad16_ Net-_U29-Pad2_ d_or
U2 Net-_U1-Pad13_ Net-_U10-Pad1_ d_buffer
U21 Net-_U1-Pad11_ Net-_U10-Pad2_ Net-_U21-Pad3_ d_and
U22 Net-_U1-Pad12_ Net-_U10-Pad1_ Net-_U22-Pad3_ d_and
U9 Net-_U10-Pad1_ Net-_U19-Pad2_ d_inverter
U28 Net-_U21-Pad3_ Net-_U22-Pad3_ Net-_U28-Pad3_ d_or
U34 Net-_U28-Pad3_ Net-_U29-Pad2_ unconnected-_U34-Pad3_ Net-_U29-Pad4_ Net-_U1-Pad17_ unconnected-_U34-Pad6_ d_dlatch
U16 Net-_U1-Pad6_ Net-_U10-Pad1_ Net-_U16-Pad3_ d_and
U15 Net-_U1-Pad5_ Net-_U15-Pad2_ Net-_U15-Pad3_ d_and
U17 Net-_U1-Pad7_ Net-_U17-Pad2_ Net-_U17-Pad3_ d_and
U7 Net-_U10-Pad1_ Net-_U15-Pad2_ d_inverter
U29 Net-_U23-Pad3_ Net-_U29-Pad2_ unconnected-_U29-Pad3_ Net-_U29-Pad4_ Net-_U1-Pad22_ unconnected-_U29-Pad6_ d_dlatch
U30 Net-_U24-Pad3_ Net-_U29-Pad2_ unconnected-_U30-Pad3_ Net-_U29-Pad4_ Net-_U1-Pad21_ unconnected-_U30-Pad6_ d_dlatch
U31 Net-_U25-Pad3_ Net-_U29-Pad2_ unconnected-_U31-Pad3_ Net-_U29-Pad4_ Net-_U1-Pad20_ unconnected-_U31-Pad6_ d_dlatch
U25 Net-_U15-Pad3_ Net-_U16-Pad3_ Net-_U25-Pad3_ d_or
U24 Net-_U13-Pad3_ Net-_U14-Pad3_ Net-_U24-Pad3_ d_or
U23 Net-_U11-Pad3_ Net-_U12-Pad3_ Net-_U23-Pad3_ d_or
U6 Net-_U10-Pad1_ Net-_U13-Pad2_ d_inverter
U5 Net-_U10-Pad1_ Net-_U11-Pad2_ d_inverter
U12 Net-_U1-Pad2_ Net-_U10-Pad1_ Net-_U12-Pad3_ d_and
U11 Net-_U1-Pad1_ Net-_U11-Pad2_ Net-_U11-Pad3_ d_and
U13 Net-_U1-Pad3_ Net-_U13-Pad2_ Net-_U13-Pad3_ d_and
U14 Net-_U1-Pad4_ Net-_U10-Pad1_ Net-_U14-Pad3_ d_and
.end
