.title KiCad schematic
U18 Net-_U10-Pad1_ Net-_U17-Pad5_ unconnected-_U18-Pad3_ Net-_U10-Pad4_ Net-_U18-Pad5_ unconnected-_U18-Pad6_ d_tff
U16 Net-_U10-Pad1_ Net-_U15-Pad5_ unconnected-_U16-Pad3_ Net-_U10-Pad4_ Net-_U16-Pad5_ unconnected-_U16-Pad6_ d_tff
U17 Net-_U10-Pad1_ Net-_U16-Pad5_ unconnected-_U17-Pad3_ Net-_U10-Pad4_ Net-_U17-Pad5_ unconnected-_U17-Pad6_ d_tff
U23 Net-_U10-Pad1_ Net-_U22-Pad5_ unconnected-_U23-Pad3_ Net-_U10-Pad4_ Net-_U23-Pad5_ unconnected-_U23-Pad6_ d_tff
U24 Net-_U10-Pad1_ Net-_U23-Pad5_ unconnected-_U24-Pad3_ Net-_U10-Pad4_ Net-_U24-Pad5_ unconnected-_U24-Pad6_ d_tff
U22 Net-_U10-Pad1_ Net-_U21-Pad5_ unconnected-_U22-Pad3_ Net-_U10-Pad4_ Net-_U22-Pad5_ unconnected-_U22-Pad6_ d_tff
U20 Net-_U10-Pad1_ Net-_U19-Pad5_ unconnected-_U20-Pad3_ Net-_U10-Pad4_ Net-_U20-Pad5_ unconnected-_U20-Pad6_ d_tff
U21 Net-_U10-Pad1_ Net-_U20-Pad5_ unconnected-_U21-Pad3_ Net-_U10-Pad4_ Net-_U21-Pad5_ unconnected-_U21-Pad6_ d_tff
U19 Net-_U10-Pad1_ Net-_U18-Pad5_ unconnected-_U19-Pad3_ Net-_U10-Pad4_ Net-_U19-Pad5_ unconnected-_U19-Pad6_ d_tff
U25 Net-_U10-Pad1_ Net-_U24-Pad5_ unconnected-_U25-Pad3_ Net-_U10-Pad4_ Net-_U25-Pad5_ unconnected-_U25-Pad6_ d_tff
U1 Net-_U2-Pad2_ Net-_U10-Pad4_ Net-_U10-Pad1_ Net-_U2-Pad5_ Net-_U3-Pad5_ Net-_U4-Pad5_ Net-_U5-Pad5_ Net-_U6-Pad5_ Net-_U7-Pad5_ Net-_U19-Pad5_ Net-_U20-Pad5_ Net-_U21-Pad5_ Net-_U22-Pad5_ Net-_U23-Pad5_ Net-_U24-Pad5_ Net-_U25-Pad5_ PORT
U14 Net-_U10-Pad1_ Net-_U13-Pad5_ unconnected-_U14-Pad3_ Net-_U10-Pad4_ Net-_U14-Pad5_ unconnected-_U14-Pad6_ d_tff
U15 Net-_U10-Pad1_ Net-_U14-Pad5_ unconnected-_U15-Pad3_ Net-_U10-Pad4_ Net-_U15-Pad5_ unconnected-_U15-Pad6_ d_tff
U10 Net-_U10-Pad1_ Net-_U10-Pad2_ unconnected-_U10-Pad3_ Net-_U10-Pad4_ Net-_U10-Pad5_ unconnected-_U10-Pad6_ d_tff
U8 Net-_U10-Pad1_ Net-_U7-Pad5_ unconnected-_U8-Pad3_ Net-_U10-Pad4_ Net-_U8-Pad5_ unconnected-_U8-Pad6_ d_tff
U9 Net-_U10-Pad1_ Net-_U8-Pad5_ unconnected-_U9-Pad3_ Net-_U10-Pad4_ Net-_U10-Pad2_ unconnected-_U9-Pad6_ d_tff
U11 Net-_U10-Pad1_ Net-_U10-Pad5_ unconnected-_U11-Pad3_ Net-_U10-Pad4_ Net-_U11-Pad5_ unconnected-_U11-Pad6_ d_tff
U12 Net-_U10-Pad1_ Net-_U11-Pad5_ unconnected-_U12-Pad3_ Net-_U10-Pad4_ Net-_U12-Pad5_ unconnected-_U12-Pad6_ d_tff
U13 Net-_U10-Pad1_ Net-_U12-Pad5_ unconnected-_U13-Pad3_ Net-_U10-Pad4_ Net-_U13-Pad5_ unconnected-_U13-Pad6_ d_tff
U7 Net-_U10-Pad1_ Net-_U6-Pad5_ unconnected-_U7-Pad3_ Net-_U10-Pad4_ Net-_U7-Pad5_ unconnected-_U7-Pad6_ d_tff
U6 Net-_U10-Pad1_ Net-_U5-Pad5_ unconnected-_U6-Pad3_ Net-_U10-Pad4_ Net-_U6-Pad5_ unconnected-_U6-Pad6_ d_tff
U5 Net-_U10-Pad1_ Net-_U4-Pad5_ unconnected-_U5-Pad3_ Net-_U10-Pad4_ Net-_U5-Pad5_ unconnected-_U5-Pad6_ d_tff
U4 Net-_U10-Pad1_ Net-_U3-Pad5_ unconnected-_U4-Pad3_ Net-_U10-Pad4_ Net-_U4-Pad5_ unconnected-_U4-Pad6_ d_tff
U2 Net-_U10-Pad1_ Net-_U2-Pad2_ unconnected-_U2-Pad3_ Net-_U10-Pad4_ Net-_U2-Pad5_ unconnected-_U2-Pad6_ d_tff
U3 Net-_U10-Pad1_ Net-_U2-Pad5_ unconnected-_U3-Pad3_ Net-_U10-Pad4_ Net-_U3-Pad5_ unconnected-_U3-Pad6_ d_tff
.end
