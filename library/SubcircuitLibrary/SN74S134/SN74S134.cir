.title KiCad schematic
U7 Net-_U4-Pad3_ Net-_U1-Pad11_ Net-_U10-Pad1_ d_and
U10 Net-_U10-Pad1_ Net-_U1-Pad12_ Net-_U10-Pad3_ d_and
U14 Net-_U13-Pad2_ Net-_U1-Pad13_ Net-_U1-Pad14_ d_and
U1 Net-_U1-Pad1_ Net-_U1-Pad2_ Net-_U1-Pad3_ Net-_U1-Pad4_ Net-_U1-Pad5_ Net-_U1-Pad6_ Net-_U1-Pad7_ Net-_U1-Pad8_ Net-_U1-Pad9_ Net-_U1-Pad10_ Net-_U1-Pad11_ Net-_U1-Pad12_ Net-_U1-Pad13_ Net-_U1-Pad14_ PORT
U13 Net-_U12-Pad3_ Net-_U13-Pad2_ d_inverter
U6 Net-_U3-Pad3_ Net-_U1-Pad7_ Net-_U6-Pad3_ d_and
U2 Net-_U1-Pad1_ Net-_U1-Pad2_ Net-_U2-Pad3_ d_and
U5 Net-_U2-Pad3_ Net-_U1-Pad3_ Net-_U5-Pad3_ d_and
U12 Net-_U11-Pad3_ Net-_U10-Pad3_ Net-_U12-Pad3_ d_and
U11 Net-_U11-Pad1_ Net-_U11-Pad2_ Net-_U11-Pad3_ d_and
U9 Net-_U6-Pad3_ Net-_U1-Pad8_ Net-_U11-Pad2_ d_and
U8 Net-_U5-Pad3_ Net-_U1-Pad4_ Net-_U11-Pad1_ d_and
U4 Net-_U1-Pad9_ Net-_U1-Pad10_ Net-_U4-Pad3_ d_and
U3 Net-_U1-Pad5_ Net-_U1-Pad6_ Net-_U3-Pad3_ d_and
.end
