.title KiCad schematic
U19 Net-_U16-Pad3_ Net-_U13-Pad3_ Net-_U19-Pad3_ d_and
U21 Net-_U19-Pad3_ Net-_U20-Pad3_ Net-_U14-Pad2_ d_or
U20 Net-_U16-Pad1_ Net-_U16-Pad2_ Net-_U20-Pad3_ d_and
U15 Net-_U14-Pad1_ Net-_U14-Pad2_ Net-_U15-Pad3_ d_xor
U18 Net-_U16-Pad3_ Net-_U13-Pad3_ Net-_U18-Pad3_ d_xor
U2 Net-_U1-Pad2_ Net-_U1-Pad6_ Net-_U12-Pad2_ d_and
U8 Net-_U12-Pad1_ Net-_U12-Pad2_ Net-_U10-Pad1_ d_xor
U17 Net-_U1-Pad2_ Net-_U1-Pad7_ Net-_U17-Pad3_ d_and
U14 Net-_U14-Pad1_ Net-_U14-Pad2_ Net-_U14-Pad3_ d_and
U16 Net-_U16-Pad1_ Net-_U16-Pad2_ Net-_U16-Pad3_ d_xor
U6 Net-_U1-Pad4_ Net-_U1-Pad6_ Net-_U6-Pad3_ d_and
U9 Net-_U6-Pad3_ Net-_U14-Pad1_ d_inverter
U13 Net-_U11-Pad3_ Net-_U12-Pad3_ Net-_U13-Pad3_ d_or
U10 Net-_U10-Pad1_ Net-_U10-Pad2_ Net-_U10-Pad3_ d_xor
U7 Net-_U4-Pad3_ Net-_U16-Pad1_ d_inverter
U12 Net-_U12-Pad1_ Net-_U12-Pad2_ Net-_U12-Pad3_ d_and
U11 Net-_U10-Pad1_ Net-_U10-Pad2_ Net-_U11-Pad3_ d_and
U5 Net-_U1-Pad3_ Net-_U1-Pad6_ Net-_U16-Pad2_ d_and
U4 Net-_U1-Pad4_ Net-_U1-Pad5_ Net-_U4-Pad3_ d_and
U3 Net-_U1-Pad3_ Net-_U1-Pad5_ Net-_U12-Pad1_ d_and
U1 Net-_U1-Pad1_ Net-_U1-Pad2_ Net-_U1-Pad3_ Net-_U1-Pad4_ Net-_U1-Pad5_ Net-_U1-Pad6_ Net-_U1-Pad7_ Net-_U1-Pad8_ Net-_U1-Pad9_ Net-_U1-Pad10_ Net-_U1-Pad11_ Net-_U1-Pad12_ Net-_U1-Pad13_ Net-_U1-Pad14_ Net-_U1-Pad15_ Net-_U1-Pad16_ PORT
U25 Net-_U18-Pad3_ Net-_U17-Pad3_ Net-_U25-Pad3_ d_and
U29 Net-_U24-Pad3_ Net-_U25-Pad3_ Net-_U29-Pad3_ d_or
U24 Net-_U22-Pad3_ Net-_U23-Pad2_ Net-_U24-Pad3_ d_and
U22 Net-_U18-Pad3_ Net-_U17-Pad3_ Net-_U22-Pad3_ d_xor
U23 Net-_U22-Pad3_ Net-_U23-Pad2_ Net-_U23-Pad3_ d_xor
U33 Net-_U1-Pad3_ Net-_U1-Pad8_ Net-_U33-Pad3_ d_and
U37 Net-_U33-Pad3_ Net-_U37-Pad2_ d_inverter
U32 Net-_U27-Pad3_ Net-_U32-Pad2_ d_inverter
U31 Net-_U26-Pad3_ Net-_U31-Pad2_ d_inverter
U30 Net-_U15-Pad3_ Net-_U28-Pad3_ Net-_U30-Pad3_ d_xor
U28 Net-_U1-Pad3_ Net-_U1-Pad7_ Net-_U28-Pad3_ d_and
U27 Net-_U1-Pad2_ Net-_U1-Pad8_ Net-_U27-Pad3_ d_and
U26 Net-_U1-Pad4_ Net-_U1-Pad7_ Net-_U26-Pad3_ d_and
U67 Net-_U41-Pad3_ Net-_U1-Pad13_ d_inverter
U36 Net-_U15-Pad3_ Net-_U28-Pad3_ Net-_U36-Pad3_ d_and
U35 Net-_U30-Pad3_ Net-_U29-Pad3_ Net-_U35-Pad3_ d_and
U38 Net-_U35-Pad3_ Net-_U36-Pad3_ Net-_U38-Pad3_ d_or
U34 Net-_U30-Pad3_ Net-_U29-Pad3_ Net-_U34-Pad3_ d_xor
U58 Net-_U55-Pad3_ Net-_U54-Pad3_ Net-_U58-Pad3_ d_and
U57 Net-_U55-Pad3_ Net-_U54-Pad3_ Net-_U57-Pad3_ d_xor
U59 Net-_U48-Pad3_ Net-_U49-Pad3_ Net-_U59-Pad3_ d_and
U64 Net-_U1-Pad1_ Net-_U1-Pad7_ Net-_U64-Pad3_ d_and
U63 Net-_U1-Pad1_ Net-_U1-Pad6_ Net-_U63-Pad3_ d_and
U61 Net-_U58-Pad3_ Net-_U59-Pad3_ Net-_U61-Pad3_ d_or
U66 Net-_U57-Pad3_ Net-_U65-Pad2_ Net-_U1-Pad15_ d_xor
U65 Net-_U57-Pad3_ Net-_U65-Pad2_ Net-_U65-Pad3_ d_and
U50 Net-_U44-Pad3_ Net-_U37-Pad2_ Net-_U50-Pad3_ d_xor
U43 Net-_U34-Pad3_ Net-_U32-Pad2_ Net-_U43-Pad3_ d_and
U42 Net-_U39-Pad3_ Net-_U41-Pad2_ Net-_U42-Pad3_ d_and
U47 Net-_U42-Pad3_ Net-_U43-Pad3_ Net-_U47-Pad3_ d_or
U53 Net-_U44-Pad3_ Net-_U37-Pad2_ Net-_U53-Pad3_ d_and
U54 Net-_U52-Pad3_ Net-_U53-Pad3_ Net-_U54-Pad3_ d_or
U51 Net-_U50-Pad3_ Net-_U47-Pad3_ Net-_U51-Pad3_ d_xor
U52 Net-_U50-Pad3_ Net-_U47-Pad3_ Net-_U52-Pad3_ d_and
U44 Net-_U40-Pad3_ Net-_U38-Pad3_ Net-_U44-Pad3_ d_xor
U45 Net-_U40-Pad3_ Net-_U38-Pad3_ Net-_U45-Pad3_ d_and
U46 Net-_U14-Pad3_ Net-_U31-Pad2_ Net-_U46-Pad3_ d_and
U48 Net-_U45-Pad3_ Net-_U46-Pad3_ Net-_U48-Pad3_ d_or
U55 Net-_U48-Pad3_ Net-_U49-Pad3_ Net-_U55-Pad3_ d_xor
U56 Net-_U1-Pad1_ Net-_U1-Pad8_ Net-_U56-Pad3_ d_and
U60 Net-_U56-Pad3_ Net-_U60-Pad2_ d_inverter
U62 Net-_U1-Pad2_ Net-_U1-Pad5_ Net-_U62-Pad3_ d_and
U40 Net-_U14-Pad3_ Net-_U31-Pad2_ Net-_U40-Pad3_ d_xor
U49 Net-_U1-Pad4_ Net-_U1-Pad8_ Net-_U49-Pad3_ d_and
U71 Net-_U61-Pad3_ Net-_U65-Pad3_ Net-_U1-Pad16_ d_xnor
U39 Net-_U34-Pad3_ Net-_U32-Pad2_ Net-_U39-Pad3_ d_xor
U41 Net-_U39-Pad3_ Net-_U41-Pad2_ Net-_U41-Pad3_ d_xor
U77 Net-_U23-Pad3_ Net-_U60-Pad2_ Net-_U1-Pad12_ d_xor
U76 Net-_U23-Pad3_ Net-_U60-Pad2_ Net-_U41-Pad2_ d_and
U73 Net-_U62-Pad3_ Net-_U63-Pad3_ Net-_U1-Pad10_ d_xor
U72 Net-_U62-Pad3_ Net-_U63-Pad3_ Net-_U10-Pad2_ d_and
U70 Net-_U1-Pad1_ Net-_U1-Pad5_ Net-_U1-Pad9_ d_and
U68 Net-_U51-Pad3_ Net-_U41-Pad3_ Net-_U65-Pad2_ d_and
U69 Net-_U51-Pad3_ Net-_U41-Pad3_ Net-_U1-Pad14_ d_xor
U74 Net-_U10-Pad3_ Net-_U64-Pad3_ Net-_U23-Pad2_ d_and
U75 Net-_U10-Pad3_ Net-_U64-Pad3_ Net-_U1-Pad11_ d_xor
.end
