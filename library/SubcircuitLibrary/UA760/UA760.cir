.title KiCad schematic
R19 Net-_Q21-Pad1_ Net-_Q11-Pad1_ 100
D3 Net-_D3-Pad1_ Net-_D3-Pad2_ eSim_Diode
Q22 Net-_D3-Pad2_ Net-_Q19-Pad3_ Net-_Q17-Pad3_ eSim_NPN
Q21 Net-_Q21-Pad1_ Net-_Q19-Pad1_ Net-_D3-Pad1_ eSim_NPN
R17 Net-_Q19-Pad1_ Net-_Q11-Pad1_ 820
U1 unconnected-_U1-Pad1_ Net-_Q3-Pad2_ Net-_Q1-Pad2_ Net-_R11-Pad1_ Net-_Q17-Pad3_ Net-_D3-Pad2_ Net-_D4-Pad2_ Net-_Q11-Pad1_ PORT
Q24 Net-_Q23-Pad3_ Net-_Q23-Pad3_ Net-_Q17-Pad3_ eSim_NPN
Q26 Net-_D4-Pad2_ Net-_Q23-Pad3_ Net-_Q17-Pad3_ eSim_NPN
Q23 Net-_Q23-Pad1_ Net-_Q13-Pad1_ Net-_Q23-Pad3_ eSim_NPN
R21 Net-_D4-Pad2_ Net-_Q23-Pad3_ 3.9K
D4 Net-_D4-Pad1_ Net-_D4-Pad2_ eSim_Diode
R20 Net-_Q23-Pad1_ Net-_Q11-Pad1_ 820
R22 Net-_Q11-Pad1_ Net-_Q25-Pad1_ 100
Q25 Net-_Q25-Pad1_ Net-_Q23-Pad1_ Net-_D4-Pad1_ eSim_NPN
R18 Net-_D3-Pad2_ Net-_Q19-Pad3_ 3.9K
Q19 Net-_Q19-Pad1_ Net-_Q19-Pad2_ Net-_Q19-Pad3_ eSim_NPN
R14 Net-_Q11-Pad2_ Net-_Q11-Pad1_ 5K
Q20 Net-_Q19-Pad3_ Net-_Q19-Pad3_ Net-_Q17-Pad3_ eSim_NPN
Q17 Net-_Q11-Pad2_ Net-_Q15-Pad3_ Net-_Q17-Pad3_ eSim_NPN
R15 Net-_Q10-Pad2_ Net-_Q17-Pad3_ 4.4K
R13 Net-_R11-Pad1_ Net-_Q16-Pad3_ 4K
Q14 Net-_Q14-Pad1_ Net-_Q10-Pad2_ Net-_Q14-Pad3_ eSim_NPN
Q18 Net-_Q10-Pad2_ Net-_Q10-Pad2_ Net-_Q18-Pad3_ eSim_NPN
R16 Net-_R11-Pad1_ Net-_Q18-Pad3_ 350
Q16 Net-_Q15-Pad3_ Net-_Q10-Pad2_ Net-_Q16-Pad3_ eSim_NPN
R11 Net-_R11-Pad1_ Net-_Q14-Pad3_ 300
R8 Net-_R11-Pad1_ Net-_Q10-Pad3_ 100
R6 Net-_R11-Pad1_ Net-_Q6-Pad3_ 350
Q8 Net-_Q10-Pad1_ Net-_Q10-Pad2_ Net-_Q10-Pad3_ eSim_NPN
Q10 Net-_Q10-Pad1_ Net-_Q10-Pad2_ Net-_Q10-Pad3_ eSim_NPN
Q12 Net-_Q10-Pad1_ Net-_Q10-Pad2_ Net-_Q10-Pad3_ eSim_NPN
R10 Net-_Q13-Pad1_ Net-_Q11-Pad3_ 620
R9 Net-_Q19-Pad2_ Net-_Q11-Pad3_ 620
R12 Net-_Q14-Pad1_ Net-_Q11-Pad3_ 1050
Q15 Net-_Q11-Pad2_ Net-_Q14-Pad1_ Net-_Q15-Pad3_ eSim_NPN
D2 Net-_D2-Pad1_ Net-_D2-Pad2_ eSim_Diode
R7 Net-_D2-Pad1_ Net-_Q7-Pad3_ 10K
Q9 Net-_Q19-Pad2_ Net-_D1-Pad1_ Net-_Q10-Pad1_ eSim_NPN
Q13 Net-_Q13-Pad1_ Net-_D2-Pad1_ Net-_Q10-Pad1_ eSim_NPN
Q11 Net-_Q11-Pad1_ Net-_Q11-Pad2_ Net-_Q11-Pad3_ eSim_NPN
Q7 Net-_Q11-Pad1_ Net-_Q3-Pad1_ Net-_Q7-Pad3_ eSim_NPN
Q4 Net-_Q11-Pad1_ Net-_Q1-Pad1_ Net-_Q4-Pad3_ eSim_NPN
Q3 Net-_Q3-Pad1_ Net-_Q3-Pad2_ Net-_Q1-Pad3_ eSim_NPN
Q1 Net-_Q1-Pad1_ Net-_Q1-Pad2_ Net-_Q1-Pad3_ eSim_NPN
R1 Net-_Q1-Pad1_ Net-_Q11-Pad1_ 1K
R3 Net-_Q3-Pad1_ Net-_Q11-Pad1_ 1K
D1 Net-_D1-Pad1_ Net-_D1-Pad2_ eSim_Diode
R5 Net-_D1-Pad1_ Net-_Q4-Pad3_ 10K
U2 Net-_D1-Pad2_ Net-_Q4-Pad3_ zener
U3 Net-_D2-Pad2_ Net-_Q7-Pad3_ zener
Q6 Net-_D2-Pad2_ Net-_Q10-Pad2_ Net-_Q6-Pad3_ eSim_NPN
R4 Net-_R11-Pad1_ Net-_Q5-Pad3_ 350
Q5 Net-_D1-Pad2_ Net-_Q10-Pad2_ Net-_Q5-Pad3_ eSim_NPN
R2 Net-_R11-Pad1_ Net-_Q2-Pad3_ 350
Q2 Net-_Q1-Pad3_ Net-_Q10-Pad2_ Net-_Q2-Pad3_ eSim_NPN
.end
