.title KiCad schematic
Q13 Net-_Q13-Pad1_ Net-_Q12-Pad1_ Net-_Q13-Pad3_ eSim_NPN
R8 Net-_Q16-Pad2_ Net-_Q9-Pad3_ 620
Q9 Net-_Q4-Pad1_ unconnected-_Q9-Pad2_ Net-_Q9-Pad3_ eSim_NPN
R10 Net-_Q11-Pad1_ Net-_Q9-Pad3_ 620
R11 Net-_Q12-Pad1_ Net-_Q9-Pad3_ 1050
Q8 Net-_Q16-Pad2_ Net-_D1-Pad1_ Net-_Q10-Pad1_ eSim_NPN
Q11 Net-_Q11-Pad1_ Net-_D2-Pad1_ Net-_Q10-Pad1_ eSim_NPN
R14 Net-_Q13-Pad1_ Net-_Q4-Pad1_ 5000
R15 Net-_Q16-Pad1_ Net-_Q4-Pad1_ 820
Q15 Net-_Q13-Pad1_ Net-_Q13-Pad3_ Net-_Q15-Pad3_ eSim_NPN
D2 Net-_D2-Pad1_ Net-_D2-Pad2_ eSim_Diode
U3 Net-_D2-Pad2_ Net-_Q6-Pad3_ zener
Q10 Net-_Q10-Pad1_ Net-_Q10-Pad2_ Net-_Q10-Pad3_ eSim_NPN
R9 Net-_R12-Pad1_ Net-_Q10-Pad3_ 100
Q3 Net-_Q3-Pad1_ Net-_Q3-Pad2_ Net-_Q1-Pad3_ eSim_NPN
R4 Net-_R12-Pad1_ Net-_Q5-Pad3_ 350
Q7 Net-_D2-Pad2_ Net-_Q10-Pad2_ Net-_Q7-Pad3_ eSim_NPN
R6 Net-_R12-Pad1_ Net-_Q7-Pad3_ 350
Q5 Net-_D1-Pad2_ Net-_Q10-Pad2_ Net-_Q5-Pad3_ eSim_NPN
Q2 Net-_Q1-Pad3_ Net-_Q10-Pad2_ Net-_Q2-Pad3_ eSim_NPN
R2 Net-_R12-Pad1_ Net-_Q2-Pad3_ 350
R7 Net-_D2-Pad1_ Net-_Q6-Pad3_ 10k
R5 Net-_D1-Pad1_ Net-_Q4-Pad3_ 10k
D1 Net-_D1-Pad1_ Net-_D1-Pad2_ eSim_Diode
Q6 Net-_Q4-Pad1_ Net-_Q3-Pad1_ Net-_Q6-Pad3_ eSim_NPN
R1 Net-_Q1-Pad1_ Net-_Q4-Pad1_ 1000
R3 Net-_Q3-Pad1_ Net-_Q4-Pad1_ 1000
Q4 Net-_Q4-Pad1_ Net-_Q1-Pad1_ Net-_Q4-Pad3_ eSim_NPN
U2 Net-_D1-Pad2_ Net-_Q4-Pad3_ zener
U1 Net-_Q3-Pad2_ Net-_Q1-Pad2_ Net-_R12-Pad1_ Net-_Q15-Pad3_ Net-_D3-Pad2_ Net-_D4-Pad2_ Net-_Q4-Pad1_ PORT
Q1 Net-_Q1-Pad1_ Net-_Q1-Pad2_ Net-_Q1-Pad3_ eSim_NPN
R17 Net-_R12-Pad1_ Net-_Q17-Pad3_ 350
Q16 Net-_Q16-Pad1_ Net-_Q16-Pad2_ Net-_Q16-Pad3_ eSim_NPN
R16 Net-_Q10-Pad2_ Net-_Q15-Pad3_ 4400
Q17 Net-_Q10-Pad2_ Net-_Q10-Pad2_ Net-_Q17-Pad3_ eSim_NPN
Q14 Net-_Q13-Pad3_ Net-_Q10-Pad2_ Net-_Q14-Pad3_ eSim_NPN
R13 Net-_R12-Pad1_ Net-_Q14-Pad3_ 4000
R12 Net-_R12-Pad1_ Net-_Q12-Pad3_ 300
Q18 Net-_Q16-Pad3_ Net-_Q16-Pad3_ Net-_Q15-Pad3_ eSim_NPN
Q12 Net-_Q12-Pad1_ Net-_Q10-Pad2_ Net-_Q12-Pad3_ eSim_NPN
R18 Net-_D3-Pad2_ Net-_Q16-Pad3_ 3900
Q20 Net-_D3-Pad2_ Net-_Q16-Pad3_ Net-_Q15-Pad3_ eSim_NPN
D3 Net-_D3-Pad1_ Net-_D3-Pad2_ eSim_Diode
Q19 Net-_Q19-Pad1_ Net-_Q16-Pad1_ Net-_D3-Pad1_ eSim_NPN
Q23 Net-_Q23-Pad1_ Net-_Q21-Pad1_ Net-_D4-Pad1_ eSim_NPN
R22 Net-_Q23-Pad1_ Net-_Q4-Pad1_ 100
D4 Net-_D4-Pad1_ Net-_D4-Pad2_ eSim_Diode
Q22 Net-_Q21-Pad3_ Net-_Q21-Pad3_ Net-_Q15-Pad3_ eSim_NPN
R21 Net-_D4-Pad2_ Net-_Q21-Pad3_ 3900
Q24 Net-_D4-Pad2_ Net-_Q21-Pad3_ Net-_Q15-Pad3_ eSim_NPN
Q21 Net-_Q21-Pad1_ Net-_Q11-Pad1_ Net-_Q21-Pad3_ eSim_NPN
R20 Net-_Q21-Pad1_ Net-_Q4-Pad1_ 820
R19 Net-_Q19-Pad1_ Net-_Q4-Pad1_ 100
.end
