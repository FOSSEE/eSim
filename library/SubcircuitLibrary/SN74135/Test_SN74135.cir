.title KiCad schematic
U4 Net-_U4-Pad1_ Net-_U4-Pad2_ adc_bridge_1
U3 Net-_U3-Pad1_ Net-_U3-Pad2_ adc_bridge_1
v2 Net-_U2-Pad1_ GND pulse
v1 Net-_U1-Pad1_ GND pulse
v4 Net-_U4-Pad1_ GND pulse
v3 Net-_U3-Pad1_ GND pulse
U1 Net-_U1-Pad1_ Net-_U1-Pad2_ adc_bridge_1
U2 Net-_U2-Pad1_ Net-_U2-Pad2_ adc_bridge_1
U5 Net-_U5-Pad1_ Net-_U5-Pad2_ adc_bridge_1
v5 Net-_U5-Pad1_ GND pulse
v6 Net-_U6-Pad1_ GND pulse
v8 Net-_U8-Pad1_ GND pulse
v7 Net-_U7-Pad1_ GND pulse
U6 Net-_U6-Pad1_ Net-_U6-Pad2_ adc_bridge_1
U8 Net-_U8-Pad1_ Net-_U8-Pad2_ adc_bridge_1
U7 Net-_U7-Pad1_ Net-_U7-Pad2_ adc_bridge_1
U16 Net-_U16-Pad1_ Z4 dac_bridge_1
U15 Net-_U15-Pad1_ Y4 dac_bridge_1
U14 Net-_U14-Pad1_ Z3 dac_bridge_1
U13 Net-_U13-Pad1_ Y3 dac_bridge_1
U10 Net-_U10-Pad1_ Z1 dac_bridge_1
U9 Net-_U9-Pad1_ Y1 dac_bridge_1
U11 Net-_U11-Pad1_ Y2 dac_bridge_1
U12 Net-_U12-Pad1_ Z2 dac_bridge_1
x1 Net-_U1-Pad2_ Net-_U2-Pad2_ Net-_U3-Pad2_ Net-_U4-Pad2_ Net-_U5-Pad2_ Net-_U6-Pad2_ Net-_U7-Pad2_ Net-_U8-Pad2_ Net-_U9-Pad1_ Net-_U10-Pad1_ Net-_U11-Pad1_ Net-_U12-Pad1_ Net-_U13-Pad1_ Net-_U14-Pad1_ Net-_U15-Pad1_ Net-_U16-Pad1_ SN74135
.end
