.title KiCad schematic
U102 Net-_U102-Pad1_ Net-_U102-Pad2_ Net-_U102-Pad3_ d_or
U105 Net-_U102-Pad3_ Net-_U105-Pad2_ d_inverter
U98 Net-_U93-Pad3_ Net-_U108-Pad1_ d_inverter
U100 Net-_U100-Pad1_ Net-_U100-Pad2_ Net-_U100-Pad3_ d_or
U104 Net-_U100-Pad3_ Net-_U104-Pad2_ Net-_U104-Pad3_ d_or
U99 Net-_U94-Pad3_ Net-_U74-Pad3_ Net-_U102-Pad1_ d_or
U107 Net-_U105-Pad2_ Net-_U107-Pad2_ d_inverter
U108 Net-_U108-Pad1_ Net-_U108-Pad2_ d_inverter
U106 Net-_U104-Pad3_ Net-_U106-Pad2_ Net-_U106-Pad3_ d_or
U109 Net-_U106-Pad3_ Net-_U109-Pad2_ d_inverter
U123 Net-_U111-Pad3_ Net-_U1-Pad13_ d_inverter
U1 Net-_U1-Pad1_ Net-_U1-Pad2_ Net-_U1-Pad3_ Net-_U1-Pad4_ Net-_U1-Pad5_ Net-_U1-Pad6_ Net-_U1-Pad7_ Net-_U1-Pad8_ Net-_U1-Pad9_ Net-_U1-Pad10_ Net-_U1-Pad11_ unconnected-_U1-Pad12_ Net-_U1-Pad13_ Net-_U1-Pad14_ Net-_U1-Pad15_ Net-_U1-Pad16_ Net-_U1-Pad17_ Net-_U1-Pad18_ Net-_U1-Pad19_ Net-_U1-Pad20_ Net-_U1-Pad21_ Net-_U1-Pad22_ Net-_U1-Pad23_ unconnected-_U1-Pad24_ PORT
U117 Net-_U112-Pad3_ Net-_U1-Pad11_ d_inverter
U118 Net-_U105-Pad2_ Net-_U1-Pad17_ d_inverter
U122 Net-_U122-Pad1_ Net-_U1-Pad15_ d_inverter
U121 Net-_U110-Pad3_ Net-_U1-Pad16_ d_inverter
U110 Net-_U107-Pad2_ Net-_U108-Pad2_ Net-_U110-Pad3_ d_or
U111 Net-_U111-Pad1_ Net-_U109-Pad2_ Net-_U111-Pad3_ d_xor
U112 Net-_U112-Pad1_ Net-_U103-Pad2_ Net-_U112-Pad3_ d_xor
U101 Net-_U101-Pad1_ Net-_U101-Pad2_ Net-_U101-Pad3_ d_or
U103 Net-_U101-Pad3_ Net-_U103-Pad2_ d_inverter
U116 Net-_U111-Pad3_ Net-_U112-Pad3_ Net-_U116-Pad3_ d_and
U119 Net-_U116-Pad3_ Net-_U113-Pad3_ Net-_U119-Pad3_ d_and
U120 Net-_U113-Pad3_ Net-_U1-Pad10_ d_inverter
U124 Net-_U119-Pad3_ Net-_U114-Pad3_ Net-_U1-Pad14_ d_and
U114 Net-_U114-Pad1_ Net-_U114-Pad2_ Net-_U114-Pad3_ d_xor
U113 Net-_U113-Pad1_ Net-_U113-Pad2_ Net-_U113-Pad3_ d_xor
U115 Net-_U114-Pad3_ Net-_U1-Pad9_ d_inverter
U14 Net-_U1-Pad6_ Net-_U1-Pad20_ Net-_U14-Pad3_ d_and
U15 Net-_U1-Pad21_ Net-_U1-Pad21_ Net-_U15-Pad3_ d_and
U12 Net-_U1-Pad21_ Net-_U1-Pad4_ Net-_U12-Pad3_ d_and
U13 Net-_U13-Pad1_ Net-_U1-Pad5_ Net-_U13-Pad3_ d_and
U16 Net-_U1-Pad22_ Net-_U1-Pad3_ Net-_U16-Pad3_ d_and
U29 Net-_U12-Pad3_ Net-_U13-Pad1_ Net-_U29-Pad3_ d_and
U11 Net-_U1-Pad20_ Net-_U1-Pad3_ Net-_U11-Pad3_ d_and
U28 Net-_U11-Pad3_ Net-_U1-Pad21_ Net-_U28-Pad3_ d_and
U10 Net-_U1-Pad19_ Net-_U1-Pad19_ Net-_U10-Pad3_ d_and
U3 Net-_U1-Pad20_ Net-_U13-Pad1_ d_inverter
U31 Net-_U17-Pad3_ Net-_U18-Pad1_ Net-_U31-Pad3_ d_and
U30 Net-_U16-Pad3_ Net-_U1-Pad23_ Net-_U30-Pad3_ d_and
U17 Net-_U1-Pad23_ Net-_U1-Pad4_ Net-_U17-Pad3_ d_and
U18 Net-_U18-Pad1_ Net-_U1-Pad5_ Net-_U18-Pad3_ d_and
U19 Net-_U1-Pad6_ Net-_U1-Pad22_ Net-_U19-Pad3_ d_and
U4 Net-_U1-Pad22_ Net-_U18-Pad1_ d_inverter
U8 Net-_U2-Pad2_ Net-_U1-Pad5_ Net-_U35-Pad1_ d_and
U9 Net-_U1-Pad6_ Net-_U1-Pad18_ Net-_U35-Pad2_ d_and
U2 Net-_U1-Pad18_ Net-_U2-Pad2_ d_inverter
U6 Net-_U1-Pad18_ Net-_U1-Pad3_ Net-_U26-Pad1_ d_and
U7 Net-_U1-Pad19_ Net-_U1-Pad4_ Net-_U27-Pad1_ d_and
U26 Net-_U26-Pad1_ Net-_U1-Pad19_ Net-_U26-Pad3_ d_and
U27 Net-_U27-Pad1_ Net-_U2-Pad2_ Net-_U27-Pad3_ d_and
U49 Net-_U41-Pad3_ Net-_U25-Pad3_ Net-_U49-Pad3_ d_or
U53 Net-_U49-Pad3_ Net-_U53-Pad2_ d_inverter
U45 Net-_U40-Pad3_ Net-_U45-Pad2_ d_inverter
U25 Net-_U1-Pad2_ Net-_U1-Pad2_ Net-_U25-Pad3_ d_and
U22 Net-_U1-Pad2_ Net-_U1-Pad4_ Net-_U22-Pad3_ d_and
U5 Net-_U1-Pad1_ Net-_U23-Pad1_ d_inverter
U23 Net-_U23-Pad1_ Net-_U1-Pad5_ Net-_U23-Pad3_ d_and
U24 Net-_U1-Pad6_ Net-_U1-Pad1_ Net-_U24-Pad3_ d_and
U97 Net-_U92-Pad3_ Net-_U113-Pad2_ d_inverter
U71 Net-_U1-Pad7_ Net-_U45-Pad2_ Net-_U71-Pad3_ d_and
U84 Net-_U71-Pad3_ Net-_U1-Pad8_ Net-_U84-Pad3_ d_and
U70 Net-_U52-Pad2_ Net-_U1-Pad8_ Net-_U101-Pad2_ d_and
U56 Net-_U44-Pad2_ Net-_U52-Pad2_ Net-_U113-Pad1_ d_xor
U96 Net-_U90-Pad3_ Net-_U83-Pad3_ Net-_U101-Pad1_ d_or
U90 Net-_U81-Pad3_ Net-_U1-Pad8_ Net-_U90-Pad3_ d_and
U83 Net-_U69-Pad3_ Net-_U1-Pad8_ Net-_U83-Pad3_ d_and
U69 Net-_U44-Pad2_ Net-_U53-Pad2_ Net-_U69-Pad3_ d_and
U81 Net-_U68-Pad3_ Net-_U44-Pad2_ Net-_U81-Pad3_ d_and
U20 Net-_U1-Pad23_ Net-_U1-Pad23_ Net-_U20-Pad3_ d_and
U21 Net-_U1-Pad1_ Net-_U1-Pad3_ Net-_U21-Pad3_ d_and
U40 Net-_U32-Pad3_ Net-_U33-Pad3_ Net-_U40-Pad3_ d_or
U41 Net-_U23-Pad3_ Net-_U24-Pad3_ Net-_U41-Pad3_ d_or
U32 Net-_U21-Pad3_ Net-_U1-Pad2_ Net-_U32-Pad3_ d_and
U33 Net-_U22-Pad3_ Net-_U23-Pad1_ Net-_U33-Pad3_ d_and
U39 Net-_U18-Pad3_ Net-_U19-Pad3_ Net-_U39-Pad3_ d_or
U38 Net-_U30-Pad3_ Net-_U31-Pad3_ Net-_U38-Pad3_ d_or
U44 Net-_U38-Pad3_ Net-_U44-Pad2_ d_inverter
U52 Net-_U48-Pad3_ Net-_U52-Pad2_ d_inverter
U48 Net-_U39-Pad3_ Net-_U20-Pad3_ Net-_U48-Pad3_ d_or
U73 Net-_U1-Pad7_ Net-_U1-Pad8_ Net-_U73-Pad3_ d_and
U82 Net-_U73-Pad3_ Net-_U114-Pad2_ d_inverter
U72 Net-_U53-Pad2_ Net-_U1-Pad8_ Net-_U72-Pad3_ d_and
U92 Net-_U84-Pad3_ Net-_U72-Pad3_ Net-_U92-Pad3_ d_or
U57 Net-_U45-Pad2_ Net-_U53-Pad2_ Net-_U114-Pad1_ d_xor
U47 Net-_U37-Pad3_ Net-_U15-Pad3_ Net-_U47-Pad3_ d_or
U51 Net-_U47-Pad3_ Net-_U51-Pad2_ d_inverter
U43 Net-_U36-Pad3_ Net-_U43-Pad2_ d_inverter
U37 Net-_U13-Pad3_ Net-_U14-Pad3_ Net-_U37-Pad3_ d_or
U36 Net-_U28-Pad3_ Net-_U29-Pad3_ Net-_U36-Pad3_ d_or
U80 Net-_U66-Pad3_ Net-_U1-Pad8_ Net-_U104-Pad2_ d_and
U64 Net-_U1-Pad7_ Net-_U45-Pad2_ Net-_U64-Pad3_ d_and
U88 Net-_U78-Pad3_ Net-_U43-Pad2_ Net-_U88-Pad3_ d_and
U78 Net-_U64-Pad3_ Net-_U44-Pad2_ Net-_U78-Pad3_ d_and
U89 Net-_U79-Pad3_ Net-_U1-Pad8_ Net-_U100-Pad2_ d_and
U95 Net-_U88-Pad3_ Net-_U1-Pad8_ Net-_U100-Pad1_ d_and
U65 Net-_U44-Pad2_ Net-_U43-Pad2_ Net-_U65-Pad3_ d_and
U79 Net-_U65-Pad3_ Net-_U53-Pad2_ Net-_U79-Pad3_ d_and
U66 Net-_U43-Pad2_ Net-_U52-Pad2_ Net-_U66-Pad3_ d_and
U68 Net-_U1-Pad7_ Net-_U45-Pad2_ Net-_U68-Pad3_ d_and
U67 Net-_U51-Pad2_ Net-_U1-Pad8_ Net-_U106-Pad2_ d_and
U55 Net-_U43-Pad2_ Net-_U51-Pad2_ Net-_U112-Pad1_ d_xor
U85 Net-_U75-Pad3_ Net-_U53-Pad2_ Net-_U102-Pad2_ d_and
U94 Net-_U58-Pad3_ Net-_U59-Pad3_ Net-_U94-Pad3_ d_or
U91 Net-_U87-Pad3_ Net-_U122-Pad1_ d_inverter
U87 Net-_U77-Pad3_ Net-_U45-Pad2_ Net-_U87-Pad3_ d_and
U93 Net-_U86-Pad3_ Net-_U1-Pad7_ Net-_U93-Pad3_ d_and
U86 Net-_U76-Pad3_ Net-_U45-Pad2_ Net-_U86-Pad3_ d_and
U58 Net-_U50-Pad2_ Net-_U50-Pad2_ Net-_U58-Pad3_ d_and
U62 Net-_U42-Pad2_ Net-_U43-Pad2_ Net-_U62-Pad3_ d_and
U74 Net-_U60-Pad3_ Net-_U52-Pad2_ Net-_U74-Pad3_ d_and
U75 Net-_U61-Pad3_ Net-_U44-Pad2_ Net-_U75-Pad3_ d_and
U61 Net-_U42-Pad2_ Net-_U43-Pad2_ Net-_U61-Pad3_ d_and
U59 Net-_U42-Pad2_ Net-_U51-Pad2_ Net-_U59-Pad3_ d_and
U60 Net-_U42-Pad2_ Net-_U43-Pad2_ Net-_U60-Pad3_ d_and
U63 Net-_U42-Pad2_ Net-_U43-Pad2_ Net-_U63-Pad3_ d_and
U77 Net-_U63-Pad3_ Net-_U44-Pad2_ Net-_U77-Pad3_ d_and
U76 Net-_U62-Pad3_ Net-_U44-Pad2_ Net-_U76-Pad3_ d_and
U50 Net-_U46-Pad3_ Net-_U50-Pad2_ d_inverter
U46 Net-_U35-Pad3_ Net-_U10-Pad3_ Net-_U46-Pad3_ d_or
U42 Net-_U34-Pad3_ Net-_U42-Pad2_ d_inverter
U34 Net-_U26-Pad3_ Net-_U27-Pad3_ Net-_U34-Pad3_ d_or
U35 Net-_U35-Pad1_ Net-_U35-Pad2_ Net-_U35-Pad3_ d_or
U54 Net-_U42-Pad2_ Net-_U50-Pad2_ Net-_U111-Pad1_ d_xor
.end
