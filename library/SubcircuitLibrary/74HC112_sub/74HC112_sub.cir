.title KiCad schematic
U14 Net-_U12-Pad3_ Net-_U13-Pad3_ Net-_U14-Pad3_ d_or
U13 Net-_U13-Pad1_ Net-_U1-Pad8_ Net-_U13-Pad3_ d_and
U12 Net-_U1-Pad2_ Net-_U1-Pad9_ Net-_U12-Pad3_ d_and
U15 Net-_U14-Pad3_ Net-_U15-Pad2_ Net-_U11-Pad3_ Net-_U11-Pad4_ Net-_U1-Pad8_ Net-_U1-Pad9_ d_dff
U1 Net-_U1-Pad1_ Net-_U1-Pad2_ Net-_U1-Pad3_ Net-_U1-Pad4_ Net-_U1-Pad5_ Net-_U1-Pad6_ Net-_U1-Pad7_ Net-_U1-Pad8_ Net-_U1-Pad9_ PORT
U2 Net-_U1-Pad1_ Net-_U11-Pad2_ d_inverter
U3 Net-_U1-Pad1_ Net-_U15-Pad2_ d_inverter
U4 Net-_U1-Pad3_ Net-_U4-Pad2_ d_inverter
U5 Net-_U1-Pad3_ Net-_U13-Pad1_ d_inverter
U8 Net-_U1-Pad2_ Net-_U1-Pad7_ Net-_U10-Pad1_ d_and
U9 Net-_U4-Pad2_ Net-_U1-Pad6_ Net-_U10-Pad2_ d_and
U10 Net-_U10-Pad1_ Net-_U10-Pad2_ Net-_U10-Pad3_ d_or
U7 Net-_U1-Pad5_ Net-_U11-Pad4_ d_inverter
U6 Net-_U1-Pad4_ Net-_U11-Pad3_ d_inverter
U11 Net-_U10-Pad3_ Net-_U11-Pad2_ Net-_U11-Pad3_ Net-_U11-Pad4_ Net-_U1-Pad6_ Net-_U1-Pad7_ d_dff
.end
