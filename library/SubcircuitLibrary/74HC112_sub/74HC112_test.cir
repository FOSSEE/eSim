.title KiCad schematic
v2 Net-_U1-Pad2_ GND pulse
v3 Net-_U1-Pad3_ GND pulse
U1 Net-_U1-Pad1_ Net-_U1-Pad2_ Net-_U1-Pad3_ Net-_U1-Pad4_ Net-_U1-Pad5_ Net-_U1-Pad6_ adc_bridge_3
U2 Net-_U2-Pad1_ Net-_U2-Pad2_ Net-_U2-Pad2_ Net-_U2-Pad2_ Net-_U2-Pad5_ Net-_U2-Pad6_ unconnected-_U2-Pad7_ unconnected-_U2-Pad8_ adc_bridge_4
v1 Net-_U1-Pad1_ GND pulse
v5 Net-_U2-Pad2_ GND pulse
v4 Net-_U2-Pad1_ GND pulse
X1 Net-_U1-Pad4_ Net-_U1-Pad5_ Net-_U1-Pad6_ Net-_U2-Pad5_ Net-_U2-Pad6_ Net-_U3-Pad1_ Net-_U3-Pad2_ Net-_U3-Pad3_ Net-_U3-Pad4_ 74HC112
U3 Net-_U3-Pad1_ Net-_U3-Pad2_ Net-_U3-Pad3_ Net-_U3-Pad4_ Net-_U3-Pad5_ Net-_U3-Pad6_ Net-_U3-Pad7_ Net-_U3-Pad8_ dac_bridge_4
U4 Net-_U3-Pad5_ plot_v1
U5 Net-_U3-Pad6_ plot_v1
U6 Net-_U3-Pad7_ plot_v1
U7 Net-_U3-Pad8_ plot_v1
.end
