.title KiCad schematic
U18 Net-_U17-Pad5_ Net-_U12-Pad2_ Net-_U18-Pad3_ d_tristate
U21 Net-_U20-Pad5_ Net-_U12-Pad2_ Net-_U21-Pad3_ d_tristate
U19 Net-_U18-Pad3_ Net-_U1-Pad14_ d_inverter
U1 Net-_U1-Pad1_ Net-_U1-Pad2_ Net-_U1-Pad3_ Net-_U1-Pad4_ Net-_U1-Pad5_ Net-_U1-Pad6_ Net-_U1-Pad7_ Net-_U1-Pad8_ Net-_U1-Pad9_ Net-_U1-Pad10_ Net-_U1-Pad11_ Net-_U1-Pad12_ Net-_U1-Pad13_ Net-_U1-Pad14_ Net-_U1-Pad15_ Net-_U1-Pad16_ Net-_U1-Pad17_ Net-_U1-Pad18_ PORT
U22 Net-_U21-Pad3_ Net-_U1-Pad13_ d_inverter
U17 Net-_U1-Pad5_ Net-_U11-Pad2_ unconnected-_U17-Pad3_ unconnected-_U17-Pad4_ Net-_U17-Pad5_ unconnected-_U17-Pad6_ d_dlatch
U20 Net-_U1-Pad6_ Net-_U11-Pad2_ unconnected-_U20-Pad3_ unconnected-_U20-Pad4_ Net-_U20-Pad5_ unconnected-_U20-Pad6_ d_dlatch
U26 Net-_U1-Pad8_ Net-_U11-Pad2_ unconnected-_U26-Pad3_ unconnected-_U26-Pad4_ Net-_U26-Pad5_ unconnected-_U26-Pad6_ d_dlatch
U25 Net-_U24-Pad3_ Net-_U1-Pad12_ d_inverter
U24 Net-_U23-Pad5_ Net-_U12-Pad2_ Net-_U24-Pad3_ d_tristate
U23 Net-_U1-Pad7_ Net-_U11-Pad2_ unconnected-_U23-Pad3_ unconnected-_U23-Pad4_ Net-_U23-Pad5_ unconnected-_U23-Pad6_ d_dlatch
U28 Net-_U27-Pad3_ Net-_U1-Pad11_ d_inverter
U27 Net-_U26-Pad5_ Net-_U12-Pad2_ Net-_U27-Pad3_ d_tristate
U6 Net-_U5-Pad5_ Net-_U12-Pad2_ Net-_U6-Pad3_ d_tristate
U5 Net-_U1-Pad1_ Net-_U11-Pad2_ unconnected-_U5-Pad3_ unconnected-_U5-Pad4_ Net-_U5-Pad5_ unconnected-_U5-Pad6_ d_dlatch
U4 Net-_U3-Pad2_ Net-_U12-Pad2_ d_buffer
U2 Net-_U1-Pad9_ Net-_U11-Pad2_ d_inverter
U3 Net-_U1-Pad10_ Net-_U3-Pad2_ d_inverter
U15 Net-_U14-Pad5_ Net-_U12-Pad2_ Net-_U15-Pad3_ d_tristate
U11 Net-_U1-Pad3_ Net-_U11-Pad2_ unconnected-_U11-Pad3_ unconnected-_U11-Pad4_ Net-_U11-Pad5_ unconnected-_U11-Pad6_ d_dlatch
U14 Net-_U1-Pad4_ Net-_U11-Pad2_ unconnected-_U14-Pad3_ unconnected-_U14-Pad4_ Net-_U14-Pad5_ unconnected-_U14-Pad6_ d_dlatch
U16 Net-_U15-Pad3_ Net-_U1-Pad15_ d_inverter
U8 Net-_U1-Pad2_ Net-_U11-Pad2_ unconnected-_U8-Pad3_ unconnected-_U8-Pad4_ Net-_U8-Pad5_ unconnected-_U8-Pad6_ d_dlatch
U12 Net-_U11-Pad5_ Net-_U12-Pad2_ Net-_U12-Pad3_ d_tristate
U13 Net-_U12-Pad3_ Net-_U1-Pad16_ d_inverter
U7 Net-_U6-Pad3_ Net-_U1-Pad18_ d_inverter
U9 Net-_U8-Pad5_ Net-_U12-Pad2_ Net-_U10-Pad1_ d_tristate
U10 Net-_U10-Pad1_ Net-_U1-Pad17_ d_inverter
.end
