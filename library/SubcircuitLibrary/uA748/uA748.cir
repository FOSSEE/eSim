.title KiCad schematic
Q16 Net-_Q15-Pad1_ Net-_Q14-Pad3_ Net-_Q16-Pad3_ eSim_NPN
Q14 Net-_Q12-Pad3_ Net-_Q13-Pad1_ Net-_Q14-Pad3_ eSim_NPN
Q20 Net-_Q11-Pad3_ Net-_Q15-Pad1_ Net-_Q13-Pad1_ eSim_PNP
R9 Net-_Q21-Pad3_ Net-_Q19-Pad3_ 50k
R7 Net-_Q11-Pad3_ Net-_Q14-Pad3_ 50k
Q18 Net-_Q13-Pad2_ Net-_Q13-Pad2_ Net-_Q11-Pad3_ eSim_NPN
R8 Net-_Q11-Pad3_ Net-_Q16-Pad3_ 100
U1 unconnected-_U1-Pad1_ unconnected-_U1-Pad2_ Net-_Q6-Pad1_ Net-_Q8-Pad2_ Net-_Q1-Pad2_ Net-_Q11-Pad3_ unconnected-_U1-Pad7_ unconnected-_U1-Pad8_ Net-_Q3-Pad1_ Net-_Q23-Pad3_ Net-_Q12-Pad3_ Net-_Q15-Pad1_ unconnected-_U1-Pad13_ unconnected-_U1-Pad14_ PORT
Q15 Net-_Q15-Pad1_ Net-_Q12-Pad1_ Net-_Q12-Pad3_ eSim_PNP
R6 Net-_Q10-Pad2_ Net-_Q12-Pad1_ 40k
Q12 Net-_Q12-Pad1_ Net-_Q12-Pad1_ Net-_Q12-Pad3_ eSim_PNP
Q22 Net-_Q11-Pad3_ Net-_Q15-Pad1_ Net-_Q21-Pad3_ eSim_PNP
R10 Net-_Q11-Pad3_ Net-_Q13-Pad2_ 50k
Q26 Net-_Q11-Pad3_ Net-_Q21-Pad3_ Net-_Q24-Pad2_ eSim_PNP
Q24 Net-_Q13-Pad2_ Net-_Q24-Pad2_ Net-_Q23-Pad3_ eSim_PNP
R5 Net-_Q11-Pad3_ Net-_Q10-Pad3_ 10k
Q13 Net-_Q13-Pad1_ Net-_Q13-Pad2_ Net-_Q11-Pad3_ eSim_NPN
Q10 Net-_Q10-Pad1_ Net-_Q10-Pad2_ Net-_Q10-Pad3_ eSim_NPN
Q11 Net-_Q10-Pad2_ Net-_Q10-Pad2_ Net-_Q11-Pad3_ eSim_NPN
R1 Net-_Q11-Pad3_ Net-_Q4-Pad3_ 1k
Q4 Net-_Q3-Pad1_ Net-_Q4-Pad2_ Net-_Q4-Pad3_ eSim_NPN
R3 Net-_Q11-Pad3_ Net-_Q7-Pad3_ 1k
R2 Net-_Q11-Pad3_ Net-_Q4-Pad2_ 50k
R4 Net-_Q13-Pad1_ Net-_Q6-Pad1_ 300
Q7 Net-_Q6-Pad1_ Net-_Q4-Pad2_ Net-_Q7-Pad3_ eSim_NPN
Q5 Net-_Q12-Pad3_ Net-_Q3-Pad1_ Net-_Q4-Pad2_ eSim_NPN
Q17 Net-_Q17-Pad1_ Net-_Q12-Pad1_ Net-_Q12-Pad3_ eSim_PNP
Q21 Net-_Q17-Pad1_ Net-_Q19-Pad3_ Net-_Q21-Pad3_ eSim_NPN
Q19 Net-_Q17-Pad1_ Net-_Q17-Pad1_ Net-_Q19-Pad3_ eSim_NPN
Q23 Net-_Q17-Pad1_ Net-_Q23-Pad2_ Net-_Q23-Pad3_ eSim_NPN
R12 Net-_Q24-Pad2_ Net-_Q23-Pad3_ 22
Q25 Net-_Q12-Pad3_ Net-_Q17-Pad1_ Net-_Q23-Pad2_ eSim_NPN
R11 Net-_Q23-Pad3_ Net-_Q23-Pad2_ 27
Q2 Net-_Q1-Pad1_ Net-_Q1-Pad1_ Net-_Q12-Pad3_ eSim_PNP
Q6 Net-_Q6-Pad1_ Net-_Q10-Pad1_ Net-_Q6-Pad3_ eSim_PNP
Q3 Net-_Q3-Pad1_ Net-_Q10-Pad1_ Net-_Q1-Pad3_ eSim_PNP
Q1 Net-_Q1-Pad1_ Net-_Q1-Pad2_ Net-_Q1-Pad3_ eSim_NPN
Q8 Net-_Q1-Pad1_ Net-_Q8-Pad2_ Net-_Q6-Pad3_ eSim_NPN
Q9 Net-_Q10-Pad1_ Net-_Q1-Pad1_ Net-_Q12-Pad3_ eSim_PNP
.end
