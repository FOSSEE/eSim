.title KiCad schematic
Q4 Net-_Q4-Pad1_ Net-_Q4-Pad2_ Net-_Q4-Pad3_ eSim_NPN
U1 Net-_Q2-Pad1_ Net-_Q2-Pad2_ Net-_Q3-Pad2_ Net-_Q3-Pad3_ unconnected-_U1-Pad5_ Net-_Q5-Pad2_ Net-_Q5-Pad1_ Net-_Q6-Pad1_ Net-_Q6-Pad2_ unconnected-_U1-Pad10_ Net-_Q4-Pad2_ Net-_Q4-Pad3_ Net-_Q1-Pad2_ Net-_Q1-Pad1_ PORT
Q6 Net-_Q6-Pad1_ Net-_Q6-Pad2_ Net-_Q4-Pad1_ eSim_NPN
Q5 Net-_Q5-Pad1_ Net-_Q5-Pad2_ Net-_Q4-Pad1_ eSim_NPN
Q1 Net-_Q1-Pad1_ Net-_Q1-Pad2_ Net-_Q1-Pad3_ eSim_NPN
Q3 Net-_Q1-Pad3_ Net-_Q3-Pad2_ Net-_Q3-Pad3_ eSim_NPN
Q2 Net-_Q2-Pad1_ Net-_Q2-Pad2_ Net-_Q1-Pad3_ eSim_NPN
.end
