.title KiCad schematic
U4 clk Net-_U4-Pad2_ adc_bridge_1
X1 Net-_U1-Pad2_ Net-_U5-Pad1_ Net-_U2-Pad2_ Net-_U3-Pad2_ Net-_U5-Pad2_ Net-_U5-Pad3_ Net-_U2-Pad2_ Net-_U3-Pad2_ Net-_U5-Pad4_ unconnected-_X1-Pad10_ Net-_U4-Pad2_ Net-_U5-Pad5_ Net-_U2-Pad2_ Net-_U3-Pad2_ Net-_U5-Pad6_ Net-_U5-Pad7_ Net-_U2-Pad2_ Net-_U3-Pad2_ Net-_U5-Pad8_ unconnected-_X1-Pad20_ SN74S536
v3 clk GND pulse
v1 EN GND pwl
U1 EN Net-_U1-Pad2_ adc_bridge_1
U2 Net-_U2-Pad1_ Net-_U2-Pad2_ adc_bridge_1
U3 GND Net-_U3-Pad2_ adc_bridge_1
v2 Net-_U2-Pad1_ GND 5
U5 Net-_U5-Pad1_ Net-_U5-Pad2_ Net-_U5-Pad3_ Net-_U5-Pad4_ Net-_U5-Pad5_ Net-_U5-Pad6_ Net-_U5-Pad7_ Net-_U5-Pad8_ 1Q_BAR 2Q_BAR 3Q_BAR 4Q_BAR 5Q_BAR 6Q_BAR 7Q_BAR 8Q_BAR dac_bridge_8
.end
