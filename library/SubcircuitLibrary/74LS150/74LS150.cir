.title KiCad schematic
U20 Net-_U20-Pad1_ Net-_U20-Pad2_ Net-_U20-Pad3_ d_or
X17 Net-_U1-Pad23_ Net-_U2-Pad2_ Net-_U9-Pad2_ Net-_U18-Pad1_ 3_and
X18 Net-_U3-Pad2_ Net-_U4-Pad2_ Net-_U1-Pad9_ Net-_U18-Pad2_ 3_and
X16 Net-_U8-Pad2_ Net-_U7-Pad2_ Net-_U1-Pad9_ Net-_U17-Pad2_ 3_and
U19 Net-_U19-Pad1_ Net-_U19-Pad2_ Net-_U19-Pad3_ d_or
U18 Net-_U18-Pad1_ Net-_U18-Pad2_ Net-_U18-Pad3_ d_or
X19 Net-_U1-Pad22_ Net-_U5-Pad2_ Net-_U3-Pad2_ Net-_U19-Pad1_ 3_and
X21 Net-_U1-Pad21_ Net-_U2-Pad2_ Net-_U6-Pad2_ Net-_U20-Pad1_ 3_and
X20 Net-_U4-Pad2_ Net-_U9-Pad2_ Net-_U1-Pad9_ Net-_U19-Pad2_ 3_and
X33 Net-_U18-Pad3_ Net-_U19-Pad3_ Net-_U20-Pad3_ Net-_U21-Pad3_ Net-_U27-Pad1_ 4_OR
U27 Net-_U27-Pad1_ Net-_U27-Pad2_ Net-_U27-Pad3_ d_or
U28 Net-_U26-Pad3_ Net-_U27-Pad3_ Net-_U1-Pad10_ d_xnor
U1 Net-_U1-Pad1_ Net-_U1-Pad2_ Net-_U1-Pad3_ Net-_U1-Pad4_ Net-_U1-Pad5_ Net-_U1-Pad6_ Net-_U1-Pad7_ Net-_U1-Pad8_ Net-_U1-Pad9_ Net-_U1-Pad10_ Net-_U1-Pad11_ unconnected-_U1-Pad12_ Net-_U4-Pad1_ Net-_U1-Pad14_ Net-_U2-Pad1_ Net-_U1-Pad16_ Net-_U1-Pad17_ Net-_U1-Pad18_ Net-_U1-Pad19_ Net-_U1-Pad20_ Net-_U1-Pad21_ Net-_U1-Pad22_ Net-_U1-Pad23_ unconnected-_U1-Pad24_ PORT
U21 Net-_U21-Pad1_ Net-_U21-Pad2_ Net-_U21-Pad3_ d_or
X28 Net-_U8-Pad2_ Net-_U9-Pad2_ Net-_U1-Pad9_ Net-_U23-Pad2_ 3_and
X27 Net-_U1-Pad18_ Net-_U5-Pad2_ Net-_U3-Pad2_ Net-_U23-Pad1_ 3_and
X32 Net-_U6-Pad2_ Net-_U9-Pad2_ Net-_U1-Pad9_ Net-_U25-Pad2_ 3_and
X29 Net-_U1-Pad17_ Net-_U2-Pad2_ Net-_U8-Pad2_ Net-_U24-Pad1_ 3_and
X31 Net-_U1-Pad16_ Net-_U5-Pad2_ Net-_U8-Pad2_ Net-_U25-Pad1_ 3_and
X30 Net-_U6-Pad2_ Net-_U9-Pad2_ Net-_U1-Pad9_ Net-_U24-Pad2_ 3_and
U25 Net-_U25-Pad1_ Net-_U25-Pad2_ Net-_U25-Pad3_ d_or
U24 Net-_U24-Pad1_ Net-_U24-Pad2_ Net-_U24-Pad3_ d_or
U22 Net-_U22-Pad1_ Net-_U22-Pad2_ Net-_U22-Pad3_ d_or
U23 Net-_U23-Pad1_ Net-_U23-Pad2_ Net-_U23-Pad3_ d_or
X35 Net-_U22-Pad3_ Net-_U23-Pad3_ Net-_U24-Pad3_ Net-_U25-Pad3_ Net-_U27-Pad2_ 4_OR
X26 Net-_U8-Pad2_ Net-_U9-Pad2_ Net-_U1-Pad9_ Net-_U22-Pad2_ 3_and
X25 Net-_U1-Pad19_ Net-_U2-Pad2_ Net-_U3-Pad2_ Net-_U22-Pad1_ 3_and
X22 Net-_U4-Pad2_ Net-_U9-Pad2_ Net-_U1-Pad9_ Net-_U20-Pad2_ 3_and
X24 Net-_U4-Pad2_ Net-_U9-Pad2_ Net-_U1-Pad9_ Net-_U21-Pad2_ 3_and
X23 Net-_U1-Pad20_ Net-_U5-Pad2_ Net-_U6-Pad2_ Net-_U21-Pad1_ 3_and
X14 Net-_U8-Pad2_ Net-_U7-Pad2_ Net-_U1-Pad9_ Net-_U16-Pad2_ 3_and
X13 Net-_U1-Pad2_ Net-_U2-Pad2_ Net-_U6-Pad2_ Net-_U16-Pad1_ 3_and
X11 Net-_U1-Pad3_ Net-_U5-Pad2_ Net-_U3-Pad2_ Net-_U15-Pad1_ 3_and
X12 Net-_U8-Pad2_ Net-_U7-Pad2_ Net-_U1-Pad9_ Net-_U15-Pad2_ 3_and
X15 Net-_U1-Pad1_ Net-_U5-Pad2_ Net-_U6-Pad2_ Net-_U17-Pad1_ 3_and
X8 Net-_U4-Pad2_ Net-_U7-Pad2_ Net-_U1-Pad9_ Net-_U13-Pad2_ 3_and
X7 Net-_U1-Pad5_ Net-_U5-Pad2_ Net-_U6-Pad2_ Net-_U13-Pad1_ 3_and
X10 Net-_U8-Pad2_ Net-_U7-Pad2_ Net-_U1-Pad9_ Net-_U14-Pad2_ 3_and
X5 Net-_U1-Pad6_ Net-_U2-Pad2_ Net-_U6-Pad2_ Net-_U12-Pad1_ 3_and
X6 Net-_U4-Pad2_ Net-_U7-Pad2_ Net-_U1-Pad9_ Net-_U12-Pad2_ 3_and
X9 Net-_U1-Pad4_ Net-_U2-Pad2_ Net-_U3-Pad2_ Net-_U14-Pad1_ 3_and
U10 Net-_U10-Pad1_ Net-_U10-Pad2_ Net-_U10-Pad3_ d_or
X2 Net-_U4-Pad2_ Net-_U7-Pad2_ Net-_U1-Pad9_ Net-_U10-Pad2_ 3_and
X4 Net-_U4-Pad2_ Net-_U7-Pad2_ Net-_U1-Pad9_ Net-_U11-Pad2_ 3_and
X1 Net-_U1-Pad8_ Net-_U2-Pad2_ Net-_U3-Pad2_ Net-_U10-Pad1_ 3_and
X3 Net-_U1-Pad7_ Net-_U5-Pad2_ Net-_U3-Pad2_ Net-_U11-Pad1_ 3_and
U11 Net-_U11-Pad1_ Net-_U11-Pad2_ Net-_U11-Pad3_ d_or
U16 Net-_U16-Pad1_ Net-_U16-Pad2_ Net-_U16-Pad3_ d_or
U15 Net-_U15-Pad1_ Net-_U15-Pad2_ Net-_U15-Pad3_ d_or
U17 Net-_U17-Pad1_ Net-_U17-Pad2_ Net-_U17-Pad3_ d_or
X34 Net-_U14-Pad3_ Net-_U15-Pad3_ Net-_U16-Pad3_ Net-_U17-Pad3_ Net-_U26-Pad2_ 4_OR
U26 Net-_U26-Pad1_ Net-_U26-Pad2_ Net-_U26-Pad3_ d_or
U14 Net-_U14-Pad1_ Net-_U14-Pad2_ Net-_U14-Pad3_ d_or
U13 Net-_U13-Pad1_ Net-_U13-Pad2_ Net-_U13-Pad3_ d_or
U12 Net-_U12-Pad1_ Net-_U12-Pad2_ Net-_U12-Pad3_ d_or
X36 Net-_U10-Pad3_ Net-_U11-Pad3_ Net-_U12-Pad3_ Net-_U13-Pad3_ Net-_U26-Pad1_ 4_OR
U6 Net-_U3-Pad2_ Net-_U6-Pad2_ d_buffer
U8 Net-_U4-Pad2_ Net-_U8-Pad2_ d_buffer
U9 Net-_U7-Pad2_ Net-_U9-Pad2_ d_buffer
U7 Net-_U1-Pad11_ Net-_U7-Pad2_ d_inverter
U4 Net-_U4-Pad1_ Net-_U4-Pad2_ d_inverter
U2 Net-_U2-Pad1_ Net-_U2-Pad2_ d_inverter
U5 Net-_U2-Pad2_ Net-_U5-Pad2_ d_buffer
U3 Net-_U1-Pad14_ Net-_U3-Pad2_ d_inverter
.end
