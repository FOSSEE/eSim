.title KiCad schematic
U1 Net-_D1-Pad2_ Net-_D2-Pad2_ Net-_D2-Pad1_ Net-_D1-Pad1_ PORT
D2 Net-_D2-Pad1_ Net-_D2-Pad2_ eSim_Diode
R3 Net-_Q1-Pad3_ Net-_D1-Pad1_ 3.0k
D3 Net-_D1-Pad1_ Net-_D2-Pad1_ eSim_Diode
Q2 Net-_D2-Pad1_ Net-_Q1-Pad3_ Net-_D1-Pad1_ eSim_NPN
Q1 Net-_D2-Pad1_ Net-_Q1-Pad2_ Net-_Q1-Pad3_ eSim_NPN
R1 Net-_D1-Pad2_ Net-_Q1-Pad2_ 2.7k
D1 Net-_D1-Pad1_ Net-_D1-Pad2_ eSim_Diode
R2 Net-_Q1-Pad2_ Net-_Q1-Pad3_ 5.0k
.end
