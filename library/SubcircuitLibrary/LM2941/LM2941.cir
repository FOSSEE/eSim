.title KiCad schematic
I1 IN ON_OFF 1mA
V2 ON_OFF GND 1.275v
X1 ADJ ON_OFF IN Net-_QP1-Pad2_ GND LM321
QP1 VOUT Net-_QP1-Pad2_ IN pnp
V1 IN GND 10v
C1 IN GND 470n
R2 GND ADJ 3k
C2 VOUT GND 22u
R3 VOUT GND 1300
R1 ADJ VOUT 1k
.end
