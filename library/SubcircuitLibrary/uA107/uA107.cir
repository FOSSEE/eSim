.title KiCad schematic
D1 Net-_D1-Pad1_ Net-_D1-Pad2_ eSim_Diode
D2 Net-_D2-Pad1_ Net-_D1-Pad1_ eSim_Diode
Q20 Net-_Q11-Pad3_ Net-_D1-Pad2_ Net-_Q20-Pad3_ eSim_PNP
R12 Net-_Q20-Pad3_ Net-_D2-Pad1_ 30k
U1 unconnected-_U1-Pad1_ Net-_Q8-Pad2_ Net-_Q1-Pad2_ Net-_Q11-Pad3_ unconnected-_U1-Pad5_ Net-_D2-Pad1_ Net-_Q12-Pad3_ unconnected-_U1-Pad8_ PORT
R10 Net-_Q11-Pad3_ Net-_Q13-Pad2_ 50
Q17 Net-_D1-Pad2_ Net-_Q14-Pad3_ Net-_Q13-Pad2_ eSim_NPN
Q14 Net-_D1-Pad2_ Net-_C1-Pad2_ Net-_Q14-Pad3_ eSim_NPN
Q11 Net-_Q10-Pad2_ Net-_Q10-Pad2_ Net-_Q11-Pad3_ eSim_NPN
Q13 Net-_C1-Pad2_ Net-_Q13-Pad2_ Net-_Q11-Pad3_ eSim_NPN
R8 Net-_Q11-Pad3_ Net-_Q14-Pad3_ 50k
R5 Net-_C1-Pad2_ Net-_Q6-Pad1_ 300
R6 Net-_Q10-Pad2_ Net-_Q12-Pad1_ 39k
C1 Net-_C1-Pad1_ Net-_C1-Pad2_ 30p
R1 Net-_Q11-Pad3_ Net-_Q3-Pad3_ 1k
R3 Net-_Q11-Pad3_ Net-_Q7-Pad3_ 1k
R4 Net-_Q11-Pad3_ Net-_Q10-Pad3_ 5k
R2 Net-_Q11-Pad3_ Net-_Q3-Pad2_ 50k
Q7 Net-_Q6-Pad1_ Net-_Q3-Pad2_ Net-_Q7-Pad3_ eSim_NPN
Q3 Net-_Q2-Pad1_ Net-_Q3-Pad2_ Net-_Q3-Pad3_ eSim_NPN
Q10 Net-_Q10-Pad1_ Net-_Q10-Pad2_ Net-_Q10-Pad3_ eSim_NPN
Q4 Net-_Q12-Pad3_ Net-_Q2-Pad1_ Net-_Q3-Pad2_ eSim_NPN
Q1 Net-_Q1-Pad1_ Net-_Q1-Pad2_ Net-_Q1-Pad3_ eSim_NPN
Q2 Net-_Q2-Pad1_ Net-_Q10-Pad1_ Net-_Q1-Pad3_ eSim_PNP
Q8 Net-_Q1-Pad1_ Net-_Q8-Pad2_ Net-_Q6-Pad3_ eSim_NPN
Q6 Net-_Q6-Pad1_ Net-_Q10-Pad1_ Net-_Q6-Pad3_ eSim_PNP
Q5 Net-_Q1-Pad1_ Net-_Q1-Pad1_ Net-_Q12-Pad3_ eSim_PNP
Q9 Net-_Q10-Pad1_ Net-_Q1-Pad1_ Net-_Q12-Pad3_ eSim_PNP
Q12 Net-_Q12-Pad1_ Net-_Q12-Pad1_ Net-_Q12-Pad3_ eSim_PNP
R9 Net-_D1-Pad2_ Net-_Q16-Pad2_ 7.5k
R7 Net-_C1-Pad1_ Net-_Q16-Pad2_ 4.5k
Q16 Net-_C1-Pad1_ Net-_Q16-Pad2_ Net-_D1-Pad2_ eSim_NPN
Q18 Net-_C1-Pad1_ Net-_Q18-Pad2_ Net-_D2-Pad1_ eSim_NPN
Q15 Net-_C1-Pad1_ Net-_Q12-Pad1_ Net-_Q12-Pad3_ eSim_PNP
R11 Net-_Q18-Pad2_ Net-_D2-Pad1_ 25
Q19 Net-_Q12-Pad3_ Net-_C1-Pad1_ Net-_Q18-Pad2_ eSim_NPN
.end
