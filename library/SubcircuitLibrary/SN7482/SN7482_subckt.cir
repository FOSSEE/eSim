.title KiCad schematic
U13 Net-_U11-Pad3_ B2 Net-_U13-Pad3_ d_and
U12 B2 A2 Net-_U12-Pad3_ d_and
U14 Net-_U11-Pad3_ A2 Net-_U14-Pad3_ d_and
U23 Net-_U19-Pad3_ Net-_U14-Pad3_ C2 d_or
U1 A1 B1 C0 A2 B2 S1 S2 C2 PORT
U19 Net-_U12-Pad3_ Net-_U13-Pad3_ Net-_U19-Pad3_ d_or
U21 Net-_U11-Pad3_ Net-_U21-Pad2_ d_inverter
U4 A2 Net-_U4-Pad2_ d_inverter
U8 B2 Net-_U4-Pad2_ Net-_U11-Pad1_ d_and
U9 Net-_U5-Pad2_ A2 Net-_U11-Pad2_ d_and
U11 Net-_U11-Pad1_ Net-_U11-Pad2_ Net-_U11-Pad3_ d_or
U5 B2 Net-_U5-Pad2_ d_inverter
U7 Net-_U3-Pad2_ A1 Net-_U10-Pad2_ d_and
U6 B1 Net-_U2-Pad2_ Net-_U10-Pad1_ d_and
U2 A1 Net-_U2-Pad2_ d_inverter
U3 B1 Net-_U3-Pad2_ d_inverter
U20 C0 Net-_U20-Pad2_ d_inverter
U18 Net-_U10-Pad3_ Net-_U18-Pad2_ d_inverter
U10 Net-_U10-Pad1_ Net-_U10-Pad2_ Net-_U10-Pad3_ d_or
U17 C0 A1 Net-_U17-Pad3_ d_and
U15 B1 A1 Net-_U15-Pad3_ d_and
U16 B1 C0 Net-_U16-Pad3_ d_and
U22 Net-_U15-Pad3_ Net-_U16-Pad3_ Net-_U22-Pad3_ d_or
U26 Net-_U22-Pad3_ Net-_U17-Pad3_ C1 d_or
U25 Net-_U20-Pad2_ Net-_U10-Pad3_ Net-_U25-Pad3_ d_and
U24 C0 Net-_U18-Pad2_ Net-_U24-Pad3_ d_and
U27 Net-_U24-Pad3_ Net-_U25-Pad3_ S1 d_or
U28 C1 Net-_U28-Pad2_ d_inverter
U30 C1 Net-_U21-Pad2_ Net-_U30-Pad3_ d_and
U29 Net-_U28-Pad2_ Net-_U11-Pad3_ Net-_U29-Pad3_ d_and
U31 Net-_U29-Pad3_ Net-_U30-Pad3_ S2 d_or
.end
