.title KiCad schematic
R6 Net-_Q2-Pad3_ Net-_Q6-Pad3_ 1.6k
Q6 Net-_Q6-Pad1_ Net-_D3-Pad1_ Net-_Q6-Pad3_ eSim_NPN
Q9 Net-_D4-Pad1_ Net-_Q5-Pad1_ Net-_Q9-Pad3_ eSim_PNP
Q7 Net-_D4-Pad1_ Net-_Q7-Pad2_ Net-_Q7-Pad3_ eSim_NPN
Q8 Net-_D5-Pad2_ Net-_Q7-Pad3_ Net-_Q2-Pad3_ eSim_NPN
Q4 Net-_D1-Pad1_ Net-_Q1-Pad1_ Net-_Q4-Pad3_ eSim_NPN
Q3 Net-_Q2-Pad1_ Net-_D2-Pad1_ Net-_Q3-Pad3_ eSim_PNP
Q2 Net-_Q2-Pad1_ Net-_Q1-Pad3_ Net-_Q2-Pad3_ eSim_NPN
R2 Net-_Q2-Pad3_ Net-_Q4-Pad3_ 1.4k
R5 Net-_Q2-Pad3_ Net-_D3-Pad2_ 500
D3 Net-_D3-Pad1_ Net-_D3-Pad2_ eSim_Diode
R4 Net-_D3-Pad1_ Net-_D2-Pad2_ 5.4k
D2 Net-_D2-Pad1_ Net-_D2-Pad2_ eSim_Diode
Q1 Net-_Q1-Pad1_ Net-_Q1-Pad2_ Net-_Q1-Pad3_ eSim_NPN
U1 Net-_Q14-Pad3_ Net-_Q10-Pad3_ Net-_D1-Pad1_ Net-_Q4-Pad3_ Net-_Q1-Pad2_ Net-_Q2-Pad3_ Net-_Q7-Pad2_ PORT
D1 Net-_D1-Pad1_ Net-_D1-Pad2_ eSim_Diode
R1 Net-_Q3-Pad3_ Net-_D1-Pad1_ 1.4k
R3 Net-_Q5-Pad1_ Net-_D1-Pad2_ 250
Q5 Net-_Q5-Pad1_ Net-_D1-Pad2_ Net-_D2-Pad1_ eSim_NPN
R7 Net-_Q9-Pad3_ Net-_D1-Pad1_ 460
Q14 Net-_Q10-Pad3_ Net-_Q12-Pad3_ Net-_Q14-Pad3_ eSim_NPN
Q11 Net-_D1-Pad1_ Net-_D4-Pad1_ Net-_Q11-Pad3_ eSim_NPN
R8 Net-_Q10-Pad3_ Net-_Q6-Pad1_ 10k
Q10 Net-_Q10-Pad1_ Net-_D5-Pad2_ Net-_Q10-Pad3_ eSim_PNP
Q13 Net-_D1-Pad1_ Net-_Q11-Pad3_ Net-_Q10-Pad3_ eSim_NPN
Q12 Net-_Q10-Pad3_ Net-_Q10-Pad1_ Net-_Q12-Pad3_ eSim_NPN
R9 Net-_Q2-Pad3_ Net-_Q10-Pad1_ 7.0k
D5 Net-_D4-Pad2_ Net-_D5-Pad2_ eSim_Diode
D4 Net-_D4-Pad1_ Net-_D4-Pad2_ eSim_Diode
.end
