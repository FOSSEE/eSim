.title KiCad schematic
X1 Net-_U1-Pad2_ Net-_U2-Pad3_ Net-_U3-Pad9_ Net-_U3-Pad10_ Net-_U3-Pad11_ Net-_U3-Pad12_ Net-_U3-Pad13_ Net-_U3-Pad14_ Net-_U3-Pad15_ Net-_U3-Pad16_ Net-_U2-Pad4_ Net-_U5-Pad2_ Net-_U6-Pad2_ Net-_U4-Pad8_ Net-_U4-Pad7_ Net-_U4-Pad6_ Net-_U4-Pad5_ Net-_U4-Pad4_ Net-_U4-Pad3_ Net-_U4-Pad2_ Net-_U4-Pad1_ Net-_U6-Pad1_ SN74LS498
U2 I0 I1 Net-_U2-Pad3_ Net-_U2-Pad4_ adc_bridge_2
U3 GND Net-_U3-Pad2_ Net-_U3-Pad2_ Net-_U3-Pad2_ Net-_U3-Pad2_ Net-_U3-Pad2_ GND Net-_U3-Pad2_ Net-_U3-Pad9_ Net-_U3-Pad10_ Net-_U3-Pad11_ Net-_U3-Pad12_ Net-_U3-Pad13_ Net-_U3-Pad14_ Net-_U3-Pad15_ Net-_U3-Pad16_ adc_bridge_8
v2 I0 GND pwl
U1 CLK Net-_U1-Pad2_ adc_bridge_1
v1 Net-_U3-Pad2_ GND 5
v4 CLK GND pulse
v3 I1 GND pwl
U6 Net-_U6-Pad1_ Net-_U6-Pad2_ LIRO RILO dac_bridge_2
U4 Net-_U4-Pad1_ Net-_U4-Pad2_ Net-_U4-Pad3_ Net-_U4-Pad4_ Net-_U4-Pad5_ Net-_U4-Pad6_ Net-_U4-Pad7_ Net-_U4-Pad8_ Q0 Q1 Q2 Q3 Q4 Q5 Q6 Q7 dac_bridge_8
U5 OC_B Net-_U5-Pad2_ adc_bridge_1
v5 OC_B GND pwl
.end
