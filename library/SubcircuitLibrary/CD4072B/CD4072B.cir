.title KiCad schematic
U13 Net-_U13-Pad1_ Net-_U13-Pad2_ Net-_U13-Pad3_ d_nand
U12 Net-_U12-Pad1_ Net-_U12-Pad2_ Net-_U12-Pad3_ d_nand
U15 Net-_U12-Pad3_ Net-_U13-Pad3_ Net-_U15-Pad3_ d_nor
U17 Net-_U15-Pad3_ Net-_U17-Pad2_ d_inverter
U19 Net-_U17-Pad2_ Net-_U1-Pad13_ d_buffer
U1 Net-_U1-Pad1_ Net-_U1-Pad2_ Net-_U1-Pad3_ Net-_U1-Pad4_ Net-_U1-Pad5_ unconnected-_U1-Pad6_ unconnected-_U1-Pad7_ unconnected-_U1-Pad8_ Net-_U1-Pad9_ Net-_U1-Pad10_ Net-_U1-Pad11_ Net-_U1-Pad12_ Net-_U1-Pad13_ unconnected-_U1-Pad14_ PORT
U14 Net-_U10-Pad3_ Net-_U11-Pad3_ Net-_U14-Pad3_ d_nor
U10 Net-_U10-Pad1_ Net-_U10-Pad2_ Net-_U10-Pad3_ d_nand
U11 Net-_U11-Pad1_ Net-_U11-Pad2_ Net-_U11-Pad3_ d_nand
U18 Net-_U16-Pad2_ Net-_U1-Pad1_ d_buffer
U16 Net-_U14-Pad3_ Net-_U16-Pad2_ d_inverter
U2 Net-_U1-Pad2_ Net-_U10-Pad1_ d_inverter
U3 Net-_U1-Pad3_ Net-_U10-Pad2_ d_inverter
U5 Net-_U1-Pad5_ Net-_U11-Pad2_ d_inverter
U4 Net-_U1-Pad4_ Net-_U11-Pad1_ d_inverter
U8 Net-_U1-Pad11_ Net-_U13-Pad1_ d_inverter
U7 Net-_U1-Pad10_ Net-_U12-Pad2_ d_inverter
U6 Net-_U1-Pad9_ Net-_U12-Pad1_ d_inverter
U9 Net-_U1-Pad12_ Net-_U13-Pad2_ d_inverter
.end
