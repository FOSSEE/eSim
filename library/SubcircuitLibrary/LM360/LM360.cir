.title KiCad schematic
R7 Net-_Q11-Pad2_ Net-_Q11-Pad1_ 1.3k
R6 Net-_Q11-Pad1_ Net-_Q25-Pad1_ 1k
Q10 Net-_Q10-Pad1_ Net-_Q10-Pad2_ Net-_Q10-Pad3_ eSim_NPN
Q9 Net-_Q13-Pad3_ Net-_Q8-Pad1_ GND eSim_NPN
Q8 Net-_Q8-Pad1_ Net-_Q7-Pad1_ Net-_Q10-Pad1_ eSim_NPN
Q11 Net-_Q11-Pad1_ Net-_Q11-Pad2_ GND eSim_NPN
R5 Net-_Q8-Pad1_ Net-_Q13-Pad3_ 1.3k
Q12 Net-_Q11-Pad2_ Net-_Q12-Pad2_ Net-_Q10-Pad1_ eSim_NPN
Q5 Net-_Q12-Pad2_ Net-_Q10-Pad2_ Net-_Q10-Pad3_ eSim_NPN
Q7 Net-_Q7-Pad1_ Net-_Q10-Pad2_ Net-_Q10-Pad3_ eSim_NPN
R2 Net-_Q10-Pad3_ Net-_Q2-Pad3_ 400
Q2 Net-_Q1-Pad3_ Net-_Q2-Pad2_ Net-_Q2-Pad3_ eSim_NPN
U4 unconnected-_U4-Pad1_ Net-_Q3-Pad2_ Net-_Q1-Pad2_ Net-_Q10-Pad3_ GND Net-_D2-Pad2_ Net-_D1-Pad2_ Net-_Q25-Pad1_ PORT
Q16 Net-_Q14-Pad1_ Net-_Q14-Pad2_ Net-_Q16-Pad3_ eSim_NPN
Q14 Net-_Q14-Pad1_ Net-_Q14-Pad2_ Net-_Q11-Pad1_ eSim_NPN
R9 Net-_Q14-Pad2_ Net-_Q25-Pad1_ 4k
Q6 Net-_Q25-Pad1_ Net-_Q1-Pad1_ Net-_Q6-Pad3_ eSim_NPN
U2 Net-_Q7-Pad1_ Net-_Q6-Pad3_ zener
Q20 Net-_Q16-Pad3_ Net-_Q14-Pad1_ Net-_D2-Pad1_ eSim_NPN
Q18 Net-_Q16-Pad3_ Net-_Q14-Pad1_ Net-_Q18-Pad3_ eSim_NPN
R12 Net-_Q24-Pad2_ Net-_Q18-Pad3_ 205
D2 Net-_D2-Pad1_ Net-_D2-Pad2_ eSim_Diode
Q23 Net-_Q23-Pad1_ Net-_Q16-Pad3_ Net-_D2-Pad1_ eSim_NPN
R15 Net-_Q16-Pad3_ Net-_Q25-Pad1_ 1.4k
R17 Net-_Q23-Pad1_ Net-_Q25-Pad1_ 85
R3 Net-_Q3-Pad1_ Net-_Q25-Pad1_ 1450
Q4 Net-_Q25-Pad1_ Net-_Q3-Pad1_ Net-_Q4-Pad3_ eSim_NPN
U1 Net-_Q12-Pad2_ Net-_Q4-Pad3_ zener
Q1 Net-_Q1-Pad1_ Net-_Q1-Pad2_ Net-_Q1-Pad3_ eSim_NPN
R1 Net-_Q1-Pad1_ Net-_Q25-Pad1_ 1450
Q3 Net-_Q3-Pad1_ Net-_Q3-Pad2_ Net-_Q1-Pad3_ eSim_NPN
U3 Net-_Q10-Pad3_ Net-_Q25-Pad2_ zener
R19 Net-_Q10-Pad2_ Net-_Q2-Pad2_ 387
R18 Net-_Q2-Pad2_ Net-_Q25-Pad3_ 3.2k
Q25 Net-_Q25-Pad1_ Net-_Q25-Pad2_ Net-_Q25-Pad3_ eSim_NPN
Q26 Net-_Q10-Pad2_ Net-_Q10-Pad2_ Net-_Q10-Pad3_ eSim_NPN
R13 GND Net-_Q24-Pad2_ 800
Q24 Net-_D2-Pad2_ Net-_Q24-Pad2_ GND eSim_NPN
R20 Net-_Q25-Pad2_ Net-_Q25-Pad1_ 5k
Q22 Net-_D1-Pad2_ Net-_Q22-Pad2_ GND eSim_NPN
R11 GND Net-_Q22-Pad2_ 800
R10 Net-_Q22-Pad2_ Net-_Q17-Pad3_ 205
D1 Net-_D1-Pad1_ Net-_D1-Pad2_ eSim_Diode
R4 Net-_Q13-Pad3_ Net-_Q25-Pad1_ 1k
Q13 Net-_Q13-Pad1_ Net-_Q13-Pad2_ Net-_Q13-Pad3_ eSim_NPN
R8 Net-_Q13-Pad2_ Net-_Q25-Pad1_ 4k
Q17 Net-_Q15-Pad3_ Net-_Q13-Pad1_ Net-_Q17-Pad3_ eSim_NPN
Q19 Net-_Q15-Pad3_ Net-_Q13-Pad1_ Net-_D1-Pad1_ eSim_NPN
R14 Net-_Q15-Pad3_ Net-_Q25-Pad1_ 1.4k
Q15 Net-_Q13-Pad1_ Net-_Q13-Pad2_ Net-_Q15-Pad3_ eSim_NPN
Q21 Net-_Q21-Pad1_ Net-_Q15-Pad3_ Net-_D1-Pad1_ eSim_NPN
R16 Net-_Q21-Pad1_ Net-_Q25-Pad1_ 85
.end
