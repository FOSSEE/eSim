.title KiCad schematic
v1 A GND pulse
v2 B GND pulse
v6 RBI GND pwl
v5 Lamp_Test GND pwl
v4 D GND pulse
v3 C GND pulse
U2 A B C D Net-_U2-Pad5_ Net-_U2-Pad6_ Net-_U2-Pad7_ Net-_U2-Pad8_ adc_bridge_4
X1 Net-_U2-Pad6_ Net-_U2-Pad7_ Net-_U3-Pad3_ Net-_U4-Pad2_ Net-_U3-Pad4_ Net-_U2-Pad8_ Net-_U2-Pad5_ unconnected-_X1-Pad8_ Net-_X1-Pad9_ Net-_X1-Pad10_ Net-_X1-Pad11_ Net-_X1-Pad12_ Net-_X1-Pad13_ Net-_X1-Pad14_ Net-_X1-Pad15_ unconnected-_X1-Pad16_ SN74LS247
v7 Net-_U4-Pad1_ GND 5
U3 Lamp_Test RBI Net-_U3-Pad3_ Net-_U3-Pad4_ adc_bridge_2
U4 Net-_U4-Pad1_ Net-_U4-Pad2_ adc_bridge_1
U6 Net-_X1-Pad14_ Net-_U6-Pad2_ d_inverter
U5 Net-_X1-Pad15_ Net-_U5-Pad2_ d_inverter
U1 Net-_U5-Pad2_ Net-_U6-Pad2_ Net-_U1-Pad3_ Net-_U1-Pad4_ Net-_U1-Pad5_ Net-_U1-Pad6_ Net-_U1-Pad7_ fout gout aout bout cout dout eout dac_bridge_7
U10 Net-_X1-Pad10_ Net-_U1-Pad6_ d_inverter
U11 Net-_X1-Pad9_ Net-_U1-Pad7_ d_inverter
U8 Net-_X1-Pad12_ Net-_U1-Pad4_ d_inverter
U9 Net-_X1-Pad11_ Net-_U1-Pad5_ d_inverter
U7 Net-_X1-Pad13_ Net-_U1-Pad3_ d_inverter
.end
