* C:\FOSSEE\eSim\library\SubcircuitLibrary\IC_LM3411\IC_LM3411.cir

* EESchema Netlist Version 1.1 (Spice format) creation date: 03/28/26 22:24:15

* To exclude a component from the Spice Netlist add [Spice_Netlist_Enabled] user FIELD set to: N
* To reorder the component spice node sequence add [Spice_Node_Sequence] user FIELD and define sequence: 2,1,0

* Sheet Name: /
Q1  Net-_C3-Pad2_ Net-_C3-Pad2_ Net-_Q1-Pad3_ eSim_NPN
Q2  Net-_C3-Pad2_ Net-_Q2-Pad2_ Net-_Q2-Pad3_ eSim_NPN
Q4  Net-_C1-Pad2_ Net-_Q4-Pad2_ Net-_Q10-Pad2_ eSim_NPN
R3  Net-_Q1-Pad3_ Net-_Q2-Pad3_ 130k
R4  Net-_Q2-Pad3_ Net-_Q3-Pad3_ 69k
R1  Net-_C3-Pad2_ Net-_Q3-Pad2_ 30.75k
R8  Net-_Q7-Pad2_ Net-_Q3-Pad3_ 45k
Q7  Net-_C2-Pad2_ Net-_Q7-Pad2_ Net-_Q10-Pad2_ eSim_NPN
R7  Net-_Q4-Pad2_ Net-_Q7-Pad2_ 10k
Q9  Net-_Q10-Pad2_ Net-_Q10-Pad1_ Net-_Q9-Pad3_ eSim_NPN
R9  Net-_Q9-Pad3_ Net-_Q11-Pad3_ 6k
Q11  Net-_Q11-Pad1_ Net-_Q10-Pad1_ Net-_Q11-Pad3_ eSim_NPN
R11  Net-_Q10-Pad1_ Net-_Q11-Pad1_ 40k
Q12  Net-_Q12-Pad1_ Net-_Q10-Pad1_ Net-_Q12-Pad3_ eSim_NPN
R13  Net-_Q12-Pad3_ Net-_Q11-Pad3_ 3.3k
R6  Net-_Q2-Pad2_ Net-_Q4-Pad2_ 20k
R5  Net-_C3-Pad2_ Net-_Q2-Pad2_ 25.5k
R14  Net-_Q16-Pad2_ Net-_Q10-Pad1_ 66k
Q16  Net-_C1-Pad1_ Net-_Q16-Pad2_ Net-_Q11-Pad3_ eSim_NPN
D1  Net-_D1-Pad1_ Net-_C1-Pad1_ eSim_Diode
R16  Net-_Q20-Pad3_ Net-_D1-Pad1_ 1k
Q20  Net-_Q20-Pad1_ Net-_C1-Pad1_ Net-_Q20-Pad3_ eSim_NPN
Q22  Net-_Q22-Pad1_ Net-_Q22-Pad1_ Net-_Q20-Pad3_ eSim_NPN
Q24  Net-_C3-Pad2_ Net-_Q22-Pad1_ Net-_D1-Pad1_ eSim_NPN
R12  Net-_Q13-Pad1_ Net-_Q12-Pad1_ 60k
R10  Net-_C3-Pad2_ Net-_Q10-Pad3_ 51k
Q14  Net-_Q14-Pad1_ Net-_C1-Pad2_ Net-_Q12-Pad1_ eSim_NPN
R15  Net-_C2-Pad1_ Net-_Q14-Pad1_ 110k
C1  Net-_C1-Pad1_ Net-_C1-Pad2_ 8p
C2  Net-_C2-Pad1_ Net-_C2-Pad2_ 5p
Q18  Net-_C2-Pad1_ Net-_C2-Pad2_ Net-_Q12-Pad1_ eSim_NPN
C3  Net-_C1-Pad1_ Net-_C3-Pad2_ 3p
R2  Net-_Q3-Pad2_ Net-_Q11-Pad3_ 110k
U1  Net-_C3-Pad2_ Net-_Q11-Pad3_ Net-_C3-Pad2_ Net-_Q3-Pad2_ Net-_D1-Pad1_ PORT
Q5  Net-_C1-Pad2_ Net-_Q13-Pad1_ Net-_C3-Pad2_ eSim_PNP
Q8  Net-_C2-Pad2_ Net-_Q13-Pad1_ Net-_C3-Pad2_ eSim_PNP
Q13  Net-_Q13-Pad1_ Net-_Q13-Pad1_ Net-_C3-Pad2_ eSim_PNP
Q15  Net-_Q14-Pad1_ Net-_Q14-Pad1_ Net-_C3-Pad2_ eSim_PNP
Q17  Net-_C2-Pad1_ Net-_Q14-Pad1_ Net-_C3-Pad2_ eSim_PNP
Q19  Net-_C1-Pad1_ Net-_C2-Pad1_ Net-_C3-Pad2_ eSim_PNP
Q21  Net-_Q20-Pad1_ Net-_Q20-Pad1_ Net-_C3-Pad2_ eSim_PNP
Q23  Net-_Q22-Pad1_ Net-_Q20-Pad1_ Net-_C3-Pad2_ eSim_PNP
Q6  Net-_Q11-Pad1_ Net-_Q3-Pad2_ Net-_Q3-Pad3_ eSim_PNP
Q3  Net-_Q11-Pad3_ Net-_Q3-Pad2_ Net-_Q3-Pad3_ eSim_PNP
Q10  Net-_Q10-Pad1_ Net-_Q10-Pad2_ Net-_Q10-Pad3_ eSim_PNP

.end
