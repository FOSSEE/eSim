.title KiCad schematic
U15 Net-_U14-Pad1_ Net-_U14-Pad2_ Net-_U15-Pad3_ d_nand
U14 Net-_U14-Pad1_ Net-_U14-Pad2_ Net-_U14-Pad3_ d_nor
U7 Net-_U1-Pad8_ Net-_U14-Pad2_ d_inverter
U6 Net-_U1-Pad7_ Net-_U14-Pad1_ d_inverter
U16 Net-_U16-Pad1_ Net-_U16-Pad2_ Net-_U16-Pad3_ d_nor
U17 Net-_U16-Pad1_ Net-_U16-Pad2_ Net-_U17-Pad3_ d_nand
U18 Net-_U1-Pad13_ Net-_U18-Pad2_ d_inverter
U9 Net-_U1-Pad10_ Net-_U16-Pad2_ d_inverter
U8 Net-_U1-Pad11_ Net-_U16-Pad1_ d_inverter
U1 Net-_U1-Pad1_ Net-_U1-Pad2_ Net-_U1-Pad3_ Net-_U1-Pad4_ unconnected-_U1-Pad5_ Net-_U1-Pad6_ Net-_U1-Pad7_ Net-_U1-Pad8_ Net-_U1-Pad9_ Net-_U1-Pad10_ Net-_U1-Pad11_ unconnected-_U1-Pad12_ Net-_U1-Pad13_ Net-_U1-Pad14_ Net-_U1-Pad15_ Net-_U1-Pad16_ PORT
U10 Net-_U10-Pad1_ Net-_U10-Pad2_ Net-_U10-Pad3_ d_nor
U11 Net-_U10-Pad1_ Net-_U10-Pad2_ Net-_U11-Pad3_ d_nand
U12 Net-_U12-Pad1_ Net-_U12-Pad2_ Net-_U12-Pad3_ d_nor
U13 Net-_U12-Pad1_ Net-_U12-Pad2_ Net-_U13-Pad3_ d_nand
U3 Net-_U1-Pad1_ Net-_U10-Pad2_ d_inverter
U2 Net-_U1-Pad16_ Net-_U10-Pad1_ d_inverter
U4 Net-_U1-Pad4_ Net-_U12-Pad1_ d_inverter
U5 Net-_U1-Pad3_ Net-_U12-Pad2_ d_inverter
U50 Net-_U50-Pad1_ Net-_U50-Pad2_ d_inverter
X7 Net-_U33-Pad2_ Net-_U40-Pad3_ Net-_U46-Pad2_ Net-_U48-Pad2_ Net-_U50-Pad1_ 4_and
U28 Net-_U22-Pad2_ Net-_U28-Pad2_ d_inverter
U36 Net-_U21-Pad2_ Net-_U28-Pad2_ Net-_U36-Pad3_ d_nand
U37 Net-_U24-Pad2_ Net-_U37-Pad2_ d_inverter
U48 Net-_U48-Pad1_ Net-_U48-Pad2_ d_inverter
U46 Net-_U46-Pad1_ Net-_U46-Pad2_ d_inverter
U47 Net-_U47-Pad1_ Net-_U47-Pad2_ d_inverter
U41 Net-_U26-Pad2_ Net-_U23-Pad2_ Net-_U41-Pad3_ d_nand
X5 Net-_U23-Pad2_ Net-_U25-Pad2_ Net-_U18-Pad2_ Net-_U47-Pad1_ 3_and
U57 Net-_U35-Pad3_ Net-_U57-Pad2_ d_inverter
U58 Net-_U50-Pad2_ Net-_U58-Pad2_ d_inverter
U60 Net-_U36-Pad3_ Net-_U60-Pad2_ d_inverter
U59 Net-_U51-Pad2_ Net-_U59-Pad2_ d_inverter
U20 Net-_U11-Pad3_ Net-_U20-Pad2_ d_inverter
U19 Net-_U10-Pad3_ Net-_U19-Pad2_ d_inverter
X4 Net-_U26-Pad2_ Net-_U21-Pad2_ Net-_U23-Pad2_ Net-_U46-Pad1_ 3_and
X6 Net-_U21-Pad2_ Net-_U23-Pad2_ Net-_U25-Pad2_ Net-_U18-Pad2_ Net-_U48-Pad1_ 4_and
U22 Net-_U13-Pad3_ Net-_U22-Pad2_ d_inverter
U21 Net-_U12-Pad3_ Net-_U21-Pad2_ d_inverter
U27 Net-_U20-Pad2_ Net-_U27-Pad2_ d_inverter
U33 Net-_U22-Pad2_ Net-_U33-Pad2_ d_inverter
U40 Net-_U24-Pad2_ Net-_U21-Pad2_ Net-_U40-Pad3_ d_nand
U35 Net-_U19-Pad2_ Net-_U27-Pad2_ Net-_U35-Pad3_ d_nand
U38 Net-_U25-Pad2_ Net-_U18-Pad2_ Net-_U38-Pad3_ d_nand
U39 Net-_U25-Pad2_ Net-_U29-Pad2_ Net-_U39-Pad3_ d_nand
U29 Net-_U26-Pad2_ Net-_U29-Pad2_ d_inverter
U49 Net-_U34-Pad2_ Net-_U38-Pad3_ Net-_U49-Pad3_ d_nand
U34 Net-_U26-Pad2_ Net-_U34-Pad2_ d_inverter
U42 Net-_U23-Pad2_ Net-_U30-Pad2_ Net-_U42-Pad3_ d_nand
U55 Net-_U39-Pad3_ Net-_U55-Pad2_ d_inverter
U54 Net-_U49-Pad3_ Net-_U54-Pad2_ d_inverter
U56 Net-_U42-Pad3_ Net-_U56-Pad2_ d_inverter
X8 Net-_U37-Pad2_ Net-_U41-Pad3_ Net-_U47-Pad2_ Net-_U51-Pad1_ 3_and
U51 Net-_U51-Pad1_ Net-_U51-Pad2_ d_inverter
U30 Net-_U24-Pad2_ Net-_U30-Pad2_ d_inverter
U26 Net-_U17-Pad3_ Net-_U26-Pad2_ d_inverter
U25 Net-_U16-Pad3_ Net-_U25-Pad2_ d_inverter
U23 Net-_U14-Pad3_ Net-_U23-Pad2_ d_inverter
U24 Net-_U15-Pad3_ Net-_U24-Pad2_ d_inverter
X3 Net-_U19-Pad2_ Net-_U21-Pad2_ Net-_U23-Pad2_ Net-_U25-Pad2_ Net-_U18-Pad2_ Net-_U45-Pad1_ 5_and
U45 Net-_U45-Pad1_ Net-_U45-Pad2_ d_inverter
X1 Net-_U24-Pad2_ Net-_U19-Pad2_ Net-_U21-Pad2_ Net-_U43-Pad1_ 3_and
U32 Net-_U22-Pad2_ Net-_U19-Pad2_ Net-_U32-Pad3_ d_nand
U44 Net-_U44-Pad1_ Net-_U44-Pad2_ d_inverter
U31 Net-_U20-Pad2_ Net-_U31-Pad2_ d_inverter
X2 Net-_U26-Pad2_ Net-_U19-Pad2_ Net-_U21-Pad2_ Net-_U23-Pad2_ Net-_U44-Pad1_ 4_and
U43 Net-_U43-Pad1_ Net-_U43-Pad2_ d_inverter
X9 Net-_U31-Pad2_ Net-_U32-Pad3_ Net-_U43-Pad2_ Net-_U44-Pad2_ Net-_U45-Pad2_ Net-_U52-Pad1_ 5_and
U52 Net-_U52-Pad1_ Net-_U52-Pad2_ d_inverter
U53 Net-_U18-Pad2_ Net-_U53-Pad2_ d_inverter
U63 Net-_U39-Pad3_ Net-_U18-Pad2_ Net-_U63-Pad3_ d_nand
U62 Net-_U55-Pad2_ Net-_U53-Pad2_ Net-_U62-Pad3_ d_nand
U77 Net-_U71-Pad3_ Net-_U1-Pad6_ d_inverter
U66 Net-_U42-Pad3_ Net-_U49-Pad3_ Net-_U66-Pad3_ d_nand
U64 Net-_U56-Pad2_ Net-_U54-Pad2_ Net-_U64-Pad3_ d_nand
U71 Net-_U64-Pad3_ Net-_U66-Pad3_ Net-_U71-Pad3_ d_nand
U72 Net-_U62-Pad3_ Net-_U63-Pad3_ Net-_U72-Pad3_ d_nand
U76 Net-_U72-Pad3_ Net-_U1-Pad9_ d_inverter
U70 Net-_U61-Pad2_ Net-_U70-Pad2_ d_inverter
U61 Net-_U52-Pad2_ Net-_U61-Pad2_ d_inverter
U74 Net-_U68-Pad3_ Net-_U69-Pad3_ Net-_U74-Pad3_ d_nand
U73 Net-_U65-Pad3_ Net-_U67-Pad3_ Net-_U73-Pad3_ d_nand
U75 Net-_U70-Pad2_ Net-_U1-Pad14_ d_inverter
U79 Net-_U73-Pad3_ Net-_U1-Pad15_ d_inverter
U78 Net-_U74-Pad3_ Net-_U1-Pad2_ d_inverter
U68 Net-_U60-Pad2_ Net-_U59-Pad2_ Net-_U68-Pad3_ d_nand
U65 Net-_U57-Pad2_ Net-_U58-Pad2_ Net-_U65-Pad3_ d_nand
U67 Net-_U35-Pad3_ Net-_U50-Pad2_ Net-_U67-Pad3_ d_nand
U69 Net-_U36-Pad3_ Net-_U51-Pad2_ Net-_U69-Pad3_ d_nand
.end
