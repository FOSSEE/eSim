.title KiCad schematic
U29 unconnected-_U29-Pad1_ Net-_U1-Pad9_ Net-_U29-Pad3_ d_nand
U7 unconnected-_U7-Pad1_ Net-_U28-Pad1_ d_inverter
U28 Net-_U28-Pad1_ Net-_U1-Pad9_ Net-_U28-Pad3_ d_and
U14 Net-_U1-Pad10_ Net-_U14-Pad2_ d_inverter
U40 Net-_U24-Pad3_ Net-_U13-Pad2_ Net-_U1-Pad18_ d_and
U24 Net-_U24-Pad1_ Net-_U1-Pad9_ Net-_U24-Pad3_ d_and
U23 Net-_U1-Pad7_ Net-_U1-Pad9_ Net-_U23-Pad3_ d_nand
U25 Net-_U1-Pad8_ Net-_U1-Pad9_ Net-_U25-Pad3_ d_nand
U12 Net-_U1-Pad10_ Net-_U12-Pad2_ d_inverter
U39 Net-_U23-Pad3_ Net-_U12-Pad2_ Net-_U1-Pad13_ d_and
U41 Net-_U25-Pad3_ Net-_U13-Pad2_ Net-_U1-Pad14_ d_and
U6 unconnected-_U6-Pad1_ Net-_U26-Pad1_ d_inverter
U5 Net-_U1-Pad4_ Net-_U24-Pad1_ d_inverter
U26 Net-_U26-Pad1_ Net-_U1-Pad9_ Net-_U26-Pad3_ d_and
U27 unconnected-_U27-Pad1_ Net-_U1-Pad9_ Net-_U27-Pad3_ d_nand
U13 Net-_U1-Pad10_ Net-_U13-Pad2_ d_inverter
U42 Net-_U26-Pad3_ Net-_U14-Pad2_ unconnected-_U42-Pad3_ d_and
U43 Net-_U27-Pad3_ Net-_U14-Pad2_ unconnected-_U43-Pad3_ d_and
U45 Net-_U29-Pad3_ Net-_U15-Pad2_ unconnected-_U45-Pad3_ d_and
U44 Net-_U28-Pad3_ Net-_U15-Pad2_ unconnected-_U44-Pad3_ d_and
U48 Net-_U32-Pad3_ Net-_U17-Pad2_ unconnected-_U48-Pad3_ d_and
U49 Net-_U33-Pad3_ Net-_U17-Pad2_ unconnected-_U49-Pad3_ d_and
U47 Net-_U31-Pad3_ Net-_U16-Pad2_ unconnected-_U47-Pad3_ d_and
U46 Net-_U30-Pad3_ Net-_U16-Pad2_ unconnected-_U46-Pad3_ d_and
U9 unconnected-_U9-Pad1_ Net-_U32-Pad1_ d_inverter
U16 Net-_U1-Pad10_ Net-_U16-Pad2_ d_inverter
U32 Net-_U32-Pad1_ Net-_U1-Pad9_ Net-_U32-Pad3_ d_and
U17 Net-_U1-Pad10_ Net-_U17-Pad2_ d_inverter
U33 unconnected-_U33-Pad1_ Net-_U1-Pad9_ Net-_U33-Pad3_ d_nand
U8 unconnected-_U8-Pad1_ Net-_U30-Pad1_ d_inverter
U31 unconnected-_U31-Pad1_ Net-_U1-Pad9_ Net-_U31-Pad3_ d_nand
U30 Net-_U30-Pad1_ Net-_U1-Pad9_ Net-_U30-Pad3_ d_and
U15 Net-_U1-Pad10_ Net-_U15-Pad2_ d_inverter
U1 Net-_U1-Pad1_ Net-_U1-Pad2_ Net-_U1-Pad3_ Net-_U1-Pad4_ Net-_U1-Pad5_ Net-_U1-Pad6_ Net-_U1-Pad7_ Net-_U1-Pad8_ Net-_U1-Pad9_ Net-_U1-Pad10_ Net-_U1-Pad11_ Net-_U1-Pad12_ Net-_U1-Pad13_ Net-_U1-Pad14_ Net-_U1-Pad15_ Net-_U1-Pad16_ Net-_U1-Pad17_ Net-_U1-Pad18_ PORT
U4 Net-_U1-Pad3_ Net-_U22-Pad1_ d_inverter
U3 Net-_U1-Pad2_ Net-_U20-Pad1_ d_inverter
U22 Net-_U22-Pad1_ Net-_U1-Pad9_ Net-_U22-Pad3_ d_and
U11 Net-_U1-Pad10_ Net-_U11-Pad2_ d_inverter
U20 Net-_U20-Pad1_ Net-_U1-Pad9_ Net-_U20-Pad3_ d_and
U21 Net-_U1-Pad6_ Net-_U1-Pad9_ Net-_U21-Pad3_ d_nand
U34 Net-_U18-Pad3_ Net-_U10-Pad2_ Net-_U1-Pad15_ d_and
U35 Net-_U19-Pad3_ Net-_U10-Pad2_ Net-_U1-Pad11_ d_and
U36 Net-_U20-Pad3_ Net-_U11-Pad2_ Net-_U1-Pad16_ d_and
U37 Net-_U21-Pad3_ Net-_U11-Pad2_ Net-_U1-Pad12_ d_and
U38 Net-_U22-Pad3_ Net-_U12-Pad2_ Net-_U1-Pad17_ d_and
U10 Net-_U1-Pad10_ Net-_U10-Pad2_ d_inverter
U2 Net-_U1-Pad1_ Net-_U18-Pad1_ d_inverter
U18 Net-_U18-Pad1_ Net-_U1-Pad9_ Net-_U18-Pad3_ d_and
U19 Net-_U1-Pad5_ Net-_U1-Pad9_ Net-_U19-Pad3_ d_nand
.end
