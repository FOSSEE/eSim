.title KiCad schematic
U7 Net-_U13-Pad2_ Net-_U15-Pad2_ Net-_U11-Pad2_ d_and
U9 Net-_U15-Pad1_ Net-_U10-Pad5_ Net-_U11-Pad1_ d_and
U11 Net-_U11-Pad1_ Net-_U11-Pad2_ Net-_U11-Pad3_ d_or
U20 Net-_U17-Pad1_ Net-_U12-Pad5_ Net-_U20-Pad3_ d_or
U21 Net-_U10-Pad1_ Net-_U10-Pad6_ Net-_U21-Pad3_ d_or
U12 Net-_U10-Pad5_ Net-_U10-Pad2_ Net-_U1-Pad2_ RESET_dig Net-_U12-Pad5_ Net-_U12-Pad6_ d_dff
U8 Net-_U15-Pad1_ Net-_U10-Pad2_ Net-_U1-Pad2_ RESET_dig Net-_U10-Pad1_ Net-_U13-Pad2_ d_dff
U10 Net-_U10-Pad1_ Net-_U10-Pad2_ Net-_U1-Pad2_ RESET_dig Net-_U10-Pad5_ Net-_U10-Pad6_ d_dff
U2 CLK_dig CLK_Inhibit_dig DisplayEnableIn_Dig DisplayEnableIn_Dig Net-_U2-Pad5_ Net-_U2-Pad6_ Net-_U2-Pad7_ unconnected-_U2-Pad8_ Net-_U2-Pad9_ Net-_U2-Pad10_ Net-_U2-Pad11_ Net-_U2-Pad12_ Net-_U2-Pad13_ Net-_U18-Pad3_ RESET_dig unconnected-_U2-Pad16_ PORT
U1 GND Net-_U1-Pad2_ adc_bridge_1
U3 CLK_Inhibit_dig Net-_U3-Pad2_ d_inverter
U5 Net-_U12-Pad6_ Net-_U10-Pad2_ Net-_U1-Pad2_ RESET_dig Net-_U17-Pad1_ Net-_U15-Pad2_ d_dff
U6 Net-_U17-Pad1_ Net-_U10-Pad2_ Net-_U1-Pad2_ RESET_dig Net-_U15-Pad1_ Net-_U17-Pad2_ d_dff
U4 CLK_dig Net-_U3-Pad2_ Net-_U10-Pad2_ d_and
U22 Net-_U13-Pad2_ Net-_U10-Pad5_ unconnected-_U22-Pad3_ d_or
U13 Net-_U12-Pad5_ Net-_U13-Pad2_ Net-_U13-Pad3_ d_and
U14 Net-_U10-Pad6_ Net-_U12-Pad5_ Net-_U14-Pad3_ d_or
U19 Net-_U15-Pad1_ Net-_U13-Pad2_ Net-_U19-Pad3_ d_or
U16 Net-_U15-Pad2_ Net-_U12-Pad6_ Net-_U16-Pad3_ d_or
U18 Net-_U17-Pad2_ Net-_U10-Pad1_ Net-_U18-Pad3_ d_or
U17 Net-_U17-Pad1_ Net-_U17-Pad2_ Net-_U17-Pad3_ d_or
U15 Net-_U15-Pad1_ Net-_U15-Pad2_ Net-_U15-Pad3_ d_or
U37 Net-_U30-Pad3_ Net-_U18-Pad3_ Net-_U37-Pad3_ d_and
U29 Net-_U19-Pad3_ Net-_U14-Pad3_ Net-_U29-Pad3_ d_and
U36 Net-_U29-Pad3_ Net-_U15-Pad3_ Net-_U36-Pad3_ d_and
U30 Net-_U20-Pad3_ Net-_U17-Pad3_ Net-_U30-Pad3_ d_and
U33 Net-_U18-Pad3_ DisplayEnableIn_Dig Net-_U2-Pad13_ d_and
U32 Net-_U24-Pad3_ DisplayEnableIn_Dig Net-_U2-Pad12_ d_and
U38 Net-_U36-Pad3_ DisplayEnableIn_Dig Net-_U2-Pad9_ d_and
U24 Net-_U16-Pad3_ Net-_U17-Pad3_ Net-_U24-Pad3_ d_and
U26 Net-_U14-Pad3_ Net-_U15-Pad3_ Net-_U26-Pad3_ d_and
U25 Net-_U2-Pad5_ Cout dac_bridge_1
U31 Net-_U26-Pad3_ DisplayEnableIn_Dig Net-_U2-Pad10_ d_and
U23 Net-_U12-Pad5_ Net-_U2-Pad5_ d_inverter
U27 Cout plot_v1
U56 d plot_v1
U52 ungated_c plot_v1
U53 a plot_v1
U55 b plot_v1
U54 c plot_v1
U59 e plot_v1
U35 Net-_U13-Pad3_ Net-_U15-Pad1_ Net-_U35-Pad3_ d_or
U28 DisplayEnableIn_Dig DisplayEnableOut dac_bridge_1
U34 DisplayEnableOut plot_v1
U40 Net-_U35-Pad3_ DisplayEnableIn_Dig Net-_U2-Pad7_ d_and
U39 Net-_U37-Pad3_ Net-_U21-Pad3_ Net-_U39-Pad3_ d_and
U41 Net-_U39-Pad3_ DisplayEnableIn_Dig Net-_U41-Pad3_ d_and
U42 Net-_U11-Pad3_ DisplayEnableIn_Dig Net-_U2-Pad6_ d_and
U47 Net-_U2-Pad12_ b dac_bridge_1
U46 Net-_U2-Pad10_ a dac_bridge_1
U45 Net-_U2-Pad9_ d dac_bridge_1
U48 Net-_U2-Pad13_ c dac_bridge_1
U44 Net-_U18-Pad3_ ungated_c dac_bridge_1
U50 Net-_U2-Pad7_ g dac_bridge_1
U49 Net-_U2-Pad6_ f dac_bridge_1
U43 Net-_U41-Pad3_ Net-_U2-Pad11_ d_inverter
U51 Net-_U2-Pad11_ e dac_bridge_1
U58 g plot_v1
U57 f plot_v1
.end
