.title KiCad schematic
U14 Net-_U1-Pad17_ Net-_U14-Pad2_ d_buffer
U6 Net-_U1-Pad16_ Net-_U6-Pad2_ d_inverter
U1 Net-_U1-Pad1_ Net-_U1-Pad2_ Net-_U1-Pad3_ Net-_U1-Pad4_ Net-_U1-Pad5_ Net-_U1-Pad6_ Net-_U1-Pad7_ Net-_U1-Pad8_ Net-_U1-Pad9_ unconnected-_U1-Pad10_ Net-_U1-Pad11_ Net-_U1-Pad12_ Net-_U1-Pad13_ Net-_U1-Pad14_ Net-_U1-Pad15_ Net-_U1-Pad16_ Net-_U1-Pad17_ Net-_U1-Pad18_ Net-_U1-Pad19_ unconnected-_U1-Pad20_ PORT
U5 Net-_U1-Pad15_ Net-_U5-Pad2_ d_inverter
U13 Net-_U1-Pad8_ Net-_U13-Pad2_ d_buffer
U11 Net-_U1-Pad6_ Net-_U11-Pad2_ d_buffer
U12 Net-_U1-Pad7_ Net-_U12-Pad2_ d_buffer
U19 Net-_U1-Pad9_ Net-_U19-Pad2_ d_inverter
v1 Net-_U2-Pad1_ GND 0
U2 Net-_U2-Pad1_ Net-_U2-Pad2_ adc_bridge_1
v2 Net-_U3-Pad1_ GND 0
U3 Net-_U3-Pad1_ Net-_U20-Pad4_ adc_bridge_1
U9 Net-_U1-Pad14_ Net-_U22-Pad1_ d_buffer
U7 Net-_U1-Pad12_ Net-_U20-Pad1_ d_buffer
U8 Net-_U1-Pad13_ Net-_U21-Pad1_ d_buffer
U4 Net-_U1-Pad11_ Net-_U20-Pad2_ d_inverter
U15 Net-_U1-Pad1_ Net-_U15-Pad2_ d_buffer
U16 Net-_U1-Pad2_ Net-_U16-Pad2_ d_buffer
U17 Net-_U1-Pad3_ Net-_U17-Pad2_ d_buffer
U18 Net-_U1-Pad4_ Net-_U18-Pad2_ d_buffer
U10 Net-_U1-Pad5_ Net-_U10-Pad2_ d_buffer
U23 Net-_U10-Pad2_ Net-_U19-Pad2_ Net-_U2-Pad2_ Net-_U20-Pad4_ unconnected-_U23-Pad5_ Net-_U23-Pad6_ d_dlatch
U29 Net-_U17-Pad2_ Net-_U19-Pad2_ Net-_U2-Pad2_ Net-_U20-Pad4_ unconnected-_U29-Pad5_ Net-_U29-Pad6_ d_dlatch
U30 Net-_U18-Pad2_ Net-_U19-Pad2_ Net-_U2-Pad2_ Net-_U20-Pad4_ unconnected-_U30-Pad5_ Net-_U30-Pad6_ d_dlatch
U27 Net-_U15-Pad2_ Net-_U19-Pad2_ Net-_U2-Pad2_ Net-_U20-Pad4_ unconnected-_U27-Pad5_ Net-_U27-Pad6_ d_dlatch
U28 Net-_U16-Pad2_ Net-_U19-Pad2_ Net-_U2-Pad2_ Net-_U20-Pad4_ unconnected-_U28-Pad5_ Net-_U28-Pad6_ d_dlatch
U31 Net-_U31-Pad1_ Net-_U31-Pad2_ Net-_U31-Pad3_ d_nor
X11 Net-_X11-Pad1_ Net-_X11-Pad2_ Net-_X11-Pad3_ Net-_X11-Pad4_ Net-_U31-Pad2_ 4_OR
X10 Net-_X10-Pad1_ Net-_X10-Pad2_ Net-_X10-Pad3_ Net-_X10-Pad4_ Net-_U31-Pad1_ 4_OR
U34 Net-_U32-Pad2_ Net-_U33-Pad2_ Net-_U1-Pad18_ d_tristate
U33 Net-_U31-Pad3_ Net-_U33-Pad2_ Net-_U1-Pad19_ d_tristate
U32 Net-_U31-Pad3_ Net-_U32-Pad2_ d_inverter
U22 Net-_U22-Pad1_ Net-_U20-Pad2_ Net-_U2-Pad2_ Net-_U20-Pad4_ Net-_U22-Pad5_ Net-_U22-Pad6_ d_dlatch
X1 Net-_U5-Pad2_ Net-_U6-Pad2_ Net-_U14-Pad2_ Net-_U33-Pad2_ 3_and
U20 Net-_U20-Pad1_ Net-_U20-Pad2_ Net-_U2-Pad2_ Net-_U20-Pad4_ Net-_U20-Pad5_ Net-_U20-Pad6_ d_dlatch
U21 Net-_U21-Pad1_ Net-_U20-Pad2_ Net-_U2-Pad2_ Net-_U20-Pad4_ Net-_U21-Pad5_ Net-_U21-Pad6_ d_dlatch
X6 Net-_U20-Pad5_ Net-_U22-Pad5_ Net-_U21-Pad5_ Net-_U27-Pad6_ Net-_X10-Pad1_ 4_and
X7 Net-_U22-Pad6_ Net-_U20-Pad5_ Net-_U21-Pad5_ Net-_U28-Pad6_ Net-_X10-Pad2_ 4_and
X8 Net-_U20-Pad5_ Net-_U22-Pad5_ Net-_U21-Pad6_ Net-_U29-Pad6_ Net-_X10-Pad3_ 4_and
X9 Net-_U22-Pad6_ Net-_U20-Pad5_ Net-_U21-Pad6_ Net-_U30-Pad6_ Net-_X10-Pad4_ 4_and
X2 Net-_U22-Pad5_ Net-_U21-Pad5_ Net-_U20-Pad6_ Net-_U23-Pad6_ Net-_X11-Pad1_ 4_and
X3 Net-_U22-Pad6_ Net-_U21-Pad5_ Net-_U20-Pad6_ Net-_U24-Pad6_ Net-_X11-Pad2_ 4_and
X5 Net-_U22-Pad6_ Net-_U21-Pad6_ Net-_U20-Pad6_ Net-_U26-Pad6_ Net-_X11-Pad4_ 4_and
X4 Net-_U22-Pad5_ Net-_U21-Pad6_ Net-_U20-Pad6_ Net-_U25-Pad6_ Net-_X11-Pad3_ 4_and
U25 Net-_U12-Pad2_ Net-_U19-Pad2_ Net-_U2-Pad2_ Net-_U20-Pad4_ unconnected-_U25-Pad5_ Net-_U25-Pad6_ d_dlatch
U24 Net-_U11-Pad2_ Net-_U19-Pad2_ Net-_U2-Pad2_ Net-_U20-Pad4_ unconnected-_U24-Pad5_ Net-_U24-Pad6_ d_dlatch
U26 Net-_U13-Pad2_ Net-_U19-Pad2_ Net-_U2-Pad2_ Net-_U20-Pad4_ unconnected-_U26-Pad5_ Net-_U26-Pad6_ d_dlatch
.end
