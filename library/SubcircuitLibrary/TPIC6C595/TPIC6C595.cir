.title KiCad schematic
U17 Net-_U17-Pad1_ Net-_U1-Pad10_ unconnected-_U17-Pad3_ Net-_U10-Pad4_ Net-_U17-Pad5_ unconnected-_U17-Pad6_ d_dlatch
U24 Net-_U17-Pad5_ Net-_U20-Pad2_ Net-_U1-Pad12_ d_and
U1 unconnected-_U1-Pad1_ Net-_U1-Pad2_ Net-_U1-Pad3_ Net-_U1-Pad4_ Net-_U1-Pad5_ Net-_U1-Pad6_ Net-_U1-Pad7_ Net-_U1-Pad8_ Net-_U1-Pad9_ Net-_U1-Pad10_ Net-_U1-Pad11_ Net-_U1-Pad12_ Net-_U1-Pad13_ Net-_U1-Pad14_ Net-_U1-Pad15_ unconnected-_U1-Pad16_ PORT
U18 Net-_U10-Pad1_ Net-_U1-Pad10_ unconnected-_U18-Pad3_ Net-_U10-Pad4_ Net-_U18-Pad5_ unconnected-_U18-Pad6_ d_dlatch
U22 Net-_U18-Pad5_ Net-_U20-Pad2_ Net-_U1-Pad13_ d_and
U21 Net-_U19-Pad5_ Net-_U20-Pad2_ Net-_U1-Pad14_ d_and
U19 Net-_U10-Pad5_ Net-_U1-Pad10_ unconnected-_U19-Pad3_ Net-_U10-Pad4_ Net-_U19-Pad5_ unconnected-_U19-Pad6_ d_dlatch
U11 Net-_U10-Pad6_ Net-_U1-Pad9_ d_inverter
U15 Net-_U15-Pad1_ Net-_U1-Pad10_ unconnected-_U15-Pad3_ Net-_U10-Pad4_ Net-_U15-Pad5_ unconnected-_U15-Pad6_ d_dlatch
U16 Net-_U16-Pad1_ Net-_U1-Pad10_ unconnected-_U16-Pad3_ Net-_U10-Pad4_ Net-_U16-Pad5_ unconnected-_U16-Pad6_ d_dlatch
U27 Net-_U15-Pad5_ Net-_U20-Pad2_ Net-_U1-Pad6_ d_and
U28 Net-_U16-Pad5_ Net-_U20-Pad2_ Net-_U1-Pad11_ d_and
U7 Net-_U15-Pad1_ Net-_U1-Pad15_ unconnected-_U7-Pad3_ Net-_U10-Pad4_ Net-_U16-Pad1_ unconnected-_U7-Pad6_ d_dff
U6 Net-_U14-Pad1_ Net-_U1-Pad15_ unconnected-_U6-Pad3_ Net-_U10-Pad4_ Net-_U15-Pad1_ unconnected-_U6-Pad6_ d_dff
U8 Net-_U16-Pad1_ Net-_U1-Pad15_ unconnected-_U8-Pad3_ Net-_U10-Pad4_ Net-_U17-Pad1_ unconnected-_U8-Pad6_ d_dff
U9 Net-_U17-Pad1_ Net-_U1-Pad15_ unconnected-_U9-Pad3_ Net-_U10-Pad4_ Net-_U10-Pad1_ unconnected-_U9-Pad6_ d_dff
U10 Net-_U10-Pad1_ Net-_U1-Pad15_ unconnected-_U10-Pad3_ Net-_U10-Pad4_ Net-_U10-Pad5_ Net-_U10-Pad6_ d_dff
U2 Net-_U1-Pad7_ Net-_U10-Pad4_ d_inverter
U26 Net-_U14-Pad5_ Net-_U20-Pad2_ Net-_U1-Pad5_ d_and
U25 Net-_U13-Pad5_ Net-_U20-Pad2_ Net-_U1-Pad4_ d_and
U23 Net-_U12-Pad5_ Net-_U20-Pad2_ Net-_U1-Pad3_ d_and
U20 Net-_U1-Pad8_ Net-_U20-Pad2_ d_inverter
U14 Net-_U14-Pad1_ Net-_U1-Pad10_ unconnected-_U14-Pad3_ Net-_U10-Pad4_ Net-_U14-Pad5_ unconnected-_U14-Pad6_ d_dlatch
U13 Net-_U13-Pad1_ Net-_U1-Pad10_ unconnected-_U13-Pad3_ Net-_U10-Pad4_ Net-_U13-Pad5_ unconnected-_U13-Pad6_ d_dlatch
U12 Net-_U12-Pad1_ Net-_U1-Pad10_ unconnected-_U12-Pad3_ Net-_U10-Pad4_ Net-_U12-Pad5_ unconnected-_U12-Pad6_ d_dlatch
U3 Net-_U1-Pad2_ Net-_U1-Pad15_ unconnected-_U3-Pad3_ Net-_U10-Pad4_ Net-_U12-Pad1_ unconnected-_U3-Pad6_ d_dff
U4 Net-_U12-Pad1_ Net-_U1-Pad15_ unconnected-_U4-Pad3_ Net-_U10-Pad4_ Net-_U13-Pad1_ unconnected-_U4-Pad6_ d_dff
U5 Net-_U13-Pad1_ Net-_U1-Pad15_ unconnected-_U5-Pad3_ Net-_U10-Pad4_ Net-_U14-Pad1_ unconnected-_U5-Pad6_ d_dff
.end
