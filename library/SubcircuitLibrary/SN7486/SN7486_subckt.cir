.title KiCad schematic
U9 B4 Net-_U11-Pad2_ d_inverter
U8 A4 Net-_U10-Pad1_ d_inverter
U11 A4 Net-_U11-Pad2_ Net-_U11-Pad3_ d_and
U10 Net-_U10-Pad1_ B4 Net-_U10-Pad3_ d_and
U17 A3 Net-_U17-Pad2_ Net-_U17-Pad3_ d_and
U1 A1 B1 A2 B2 A3 B3 A4 B4 Y1 Y2 Y3 Y4 PORT
U6 A3 Net-_U16-Pad1_ d_inverter
U7 B3 Net-_U17-Pad2_ d_inverter
U5 B2 Net-_U15-Pad2_ d_inverter
U2 A1 Net-_U12-Pad1_ d_inverter
U3 B1 Net-_U13-Pad2_ d_inverter
U4 A2 Net-_U14-Pad1_ d_inverter
U19 Net-_U12-Pad3_ Net-_U13-Pad3_ Net-_U19-Pad3_ d_or
U22 Net-_U18-Pad3_ Y4 dac_bridge_1
U18 Net-_U10-Pad3_ Net-_U11-Pad3_ Net-_U18-Pad3_ d_or
U21 Net-_U16-Pad3_ Net-_U17-Pad3_ Net-_U21-Pad3_ d_or
U25 Net-_U21-Pad3_ Y3 dac_bridge_1
U16 Net-_U16-Pad1_ B3 Net-_U16-Pad3_ d_and
U15 A2 Net-_U15-Pad2_ Net-_U15-Pad3_ d_and
U13 A1 Net-_U13-Pad2_ Net-_U13-Pad3_ d_and
U14 Net-_U14-Pad1_ B2 Net-_U14-Pad3_ d_and
U12 Net-_U12-Pad1_ B1 Net-_U12-Pad3_ d_and
U20 Net-_U14-Pad3_ Net-_U15-Pad3_ Net-_U20-Pad3_ d_or
U24 Net-_U20-Pad3_ Y2 dac_bridge_1
U23 Net-_U19-Pad3_ Y1 dac_bridge_1
.end
