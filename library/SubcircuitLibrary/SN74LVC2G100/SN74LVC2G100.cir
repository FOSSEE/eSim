.title KiCad schematic
U1 Net-_U1-Pad1_ Net-_U1-Pad2_ Net-_U1-Pad3_ Net-_U1-Pad4_ Net-_U1-Pad5_ Net-_U1-Pad6_ Net-_U1-Pad7_ unconnected-_U1-Pad8_ Net-_U1-Pad9_ Net-_U1-Pad10_ Net-_U1-Pad11_ Net-_U1-Pad12_ Net-_U1-Pad13_ Net-_U1-Pad14_ Net-_U1-Pad15_ unconnected-_U1-Pad16_ PORT
U3 Net-_U1-Pad3_ Net-_U1-Pad4_ Net-_U3-Pad3_ d_and
U4 Net-_U1-Pad2_ Net-_U2-Pad2_ Net-_U4-Pad3_ d_and
U2 Net-_U1-Pad4_ Net-_U2-Pad2_ d_inverter
U5 Net-_U4-Pad3_ Net-_U3-Pad3_ Net-_U5-Pad3_ d_or
U6 Net-_U5-Pad3_ Net-_U1-Pad5_ Net-_U6-Pad3_ d_xor
U8 Net-_U1-Pad12_ Net-_U10-Pad2_ d_inverter
U12 Net-_U11-Pad3_ Net-_U1-Pad11_ Net-_U12-Pad3_ d_xor
U13 Net-_U12-Pad3_ Net-_U1-Pad9_ unconnected-_U13-Pad3_ Net-_U1-Pad15_ Net-_U1-Pad10_ unconnected-_U13-Pad6_ d_dff
U11 Net-_U10-Pad3_ Net-_U11-Pad2_ Net-_U11-Pad3_ d_or
U7 Net-_U6-Pad3_ Net-_U1-Pad7_ unconnected-_U7-Pad3_ Net-_U1-Pad1_ Net-_U1-Pad6_ unconnected-_U7-Pad6_ d_dff
U9 Net-_U1-Pad13_ Net-_U1-Pad12_ Net-_U11-Pad2_ d_and
U10 Net-_U1-Pad14_ Net-_U10-Pad2_ Net-_U10-Pad3_ d_and
.end
