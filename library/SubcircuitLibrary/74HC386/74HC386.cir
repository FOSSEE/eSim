.title KiCad schematic
U17 Net-_U1-Pad1_ Net-_U2-Pad1_ Net-_U4-Pad2_ Net-_U8-Pad2_ Net-_U5-Pad1_ Net-_U6-Pad1_ Net-_U9-Pad1_ Net-_U10-Pad1_ Net-_U12-Pad2_ Net-_U16-Pad2_ Net-_U13-Pad1_ Net-_U14-Pad1_ PORT
U10 Net-_U10-Pad1_ Net-_U10-Pad2_ d_inverter
U13 Net-_U13-Pad1_ Net-_U13-Pad2_ d_inverter
U12 Net-_U11-Pad3_ Net-_U12-Pad2_ d_inverter
U16 Net-_U15-Pad3_ Net-_U16-Pad2_ d_inverter
U14 Net-_U14-Pad1_ Net-_U14-Pad2_ d_inverter
U11 Net-_U9-Pad2_ Net-_U10-Pad2_ Net-_U11-Pad3_ d_xnor
U15 Net-_U13-Pad2_ Net-_U14-Pad2_ Net-_U15-Pad3_ d_xnor
U6 Net-_U6-Pad1_ Net-_U6-Pad2_ d_inverter
U9 Net-_U9-Pad1_ Net-_U9-Pad2_ d_inverter
U7 Net-_U5-Pad2_ Net-_U6-Pad2_ Net-_U7-Pad3_ d_xnor
U3 Net-_U1-Pad2_ Net-_U2-Pad2_ Net-_U3-Pad3_ d_xnor
U4 Net-_U3-Pad3_ Net-_U4-Pad2_ d_inverter
U8 Net-_U7-Pad3_ Net-_U8-Pad2_ d_inverter
U5 Net-_U5-Pad1_ Net-_U5-Pad2_ d_inverter
U2 Net-_U2-Pad1_ Net-_U2-Pad2_ d_inverter
U1 Net-_U1-Pad1_ Net-_U1-Pad2_ d_inverter
.end
