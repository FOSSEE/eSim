.title KiCad schematic
Q29 Net-_Q26-Pad3_ Net-_Q29-Pad2_ Net-_Q10-Pad3_ eSim_NPN
Q24 Net-_Q20-Pad2_ Net-_Q20-Pad2_ Net-_Q24-Pad3_ eSim_NPN
Q25 Net-_Q10-Pad3_ Net-_Q17-Pad1_ Net-_Q24-Pad3_ eSim_PNP
Q26 Net-_Q26-Pad1_ Net-_Q20-Pad2_ Net-_Q26-Pad3_ eSim_NPN
Q33 Net-_Q32-Pad2_ Net-_Q17-Pad1_ Net-_Q20-Pad3_ eSim_NPN
Q46 Net-_Q46-Pad1_ Net-_Q44-Pad3_ Net-_Q10-Pad3_ eSim_NPN
U1 Net-_D1-Pad1_ Net-_Q29-Pad2_ Net-_Q46-Pad1_ Net-_Q10-Pad3_ Net-_R2-Pad2_ Net-_Q1-Pad1_ Net-_Q1-Pad2_ Net-_D2-Pad1_ PORT
Q45 Net-_Q44-Pad3_ Net-_Q29-Pad2_ Net-_Q41-Pad3_ eSim_NPN
Q44 Net-_Q42-Pad1_ Net-_Q42-Pad3_ Net-_Q44-Pad3_ eSim_NPN
Q30 Net-_Q30-Pad1_ Net-_Q26-Pad1_ Net-_Q1-Pad1_ eSim_PNP
Q35 Net-_Q34-Pad3_ Net-_Q34-Pad3_ Net-_Q30-Pad1_ eSim_NPN
Q28 Net-_Q20-Pad2_ Net-_Q19-Pad2_ Net-_Q1-Pad1_ eSim_PNP
Q34 Net-_Q1-Pad1_ Net-_Q1-Pad1_ Net-_Q34-Pad3_ eSim_NPN
Q32 Net-_Q30-Pad1_ Net-_Q32-Pad2_ Net-_Q26-Pad3_ eSim_NPN
Q36 Net-_Q20-Pad2_ Net-_Q32-Pad2_ Net-_Q20-Pad3_ eSim_NPN
Q23 Net-_Q20-Pad1_ Net-_Q19-Pad2_ Net-_Q1-Pad1_ eSim_PNP
Q27 Net-_Q26-Pad1_ Net-_Q26-Pad1_ Net-_Q1-Pad1_ eSim_PNP
Q31 Net-_Q29-Pad2_ Net-_Q31-Pad2_ Net-_Q10-Pad3_ eSim_NPN
Q37 Net-_Q19-Pad2_ Net-_Q19-Pad2_ Net-_Q1-Pad1_ eSim_PNP
Q38 Net-_Q19-Pad2_ Net-_Q31-Pad2_ Net-_Q10-Pad3_ eSim_NPN
R2 Net-_Q42-Pad1_ Net-_R2-Pad2_ 500
Q39 Net-_Q39-Pad1_ Net-_Q19-Pad2_ Net-_Q1-Pad1_ eSim_PNP
Q42 Net-_Q42-Pad1_ Net-_Q40-Pad1_ Net-_Q42-Pad3_ eSim_NPN
Q40 Net-_Q40-Pad1_ Net-_Q30-Pad1_ Net-_Q39-Pad1_ eSim_PNP
R1 Net-_Q10-Pad3_ Net-_Q41-Pad3_ 50K
Q43 Net-_Q42-Pad3_ Net-_Q29-Pad2_ Net-_Q41-Pad3_ eSim_NPN
Q41 Net-_Q40-Pad1_ Net-_Q29-Pad2_ Net-_Q41-Pad3_ eSim_NPN
Q20 Net-_Q20-Pad1_ Net-_Q20-Pad2_ Net-_Q20-Pad3_ eSim_NPN
Q12 Net-_Q10-Pad1_ Net-_D2-Pad2_ Net-_Q12-Pad3_ eSim_PNP
Q15 Net-_Q10-Pad3_ Net-_D2-Pad1_ Net-_D2-Pad2_ eSim_PNP
D2 Net-_D2-Pad1_ Net-_D2-Pad2_ eSim_Diode
Q18 Net-_Q17-Pad1_ Net-_Q10-Pad1_ Net-_Q10-Pad3_ eSim_NPN
Q21 Net-_Q20-Pad3_ Net-_Q20-Pad3_ Net-_Q21-Pad3_ eSim_NPN
Q22 Net-_Q21-Pad3_ Net-_Q21-Pad3_ Net-_Q10-Pad3_ eSim_NPN
Q11 Net-_Q11-Pad1_ Net-_Q11-Pad2_ Net-_Q11-Pad3_ eSim_NPN
Q7 Net-_Q11-Pad3_ Net-_Q29-Pad2_ Net-_Q10-Pad3_ eSim_NPN
Q4 Net-_Q4-Pad1_ Net-_Q1-Pad3_ Net-_Q11-Pad3_ eSim_NPN
Q6 Net-_Q4-Pad1_ Net-_Q4-Pad1_ Net-_Q1-Pad1_ eSim_PNP
Q1 Net-_Q1-Pad1_ Net-_Q1-Pad2_ Net-_Q1-Pad3_ eSim_NPN
Q16 Net-_Q1-Pad1_ Net-_D2-Pad1_ Net-_Q11-Pad2_ eSim_NPN
Q9 Net-_Q11-Pad1_ Net-_Q4-Pad1_ Net-_Q1-Pad1_ eSim_PNP
Q13 Net-_Q1-Pad1_ Net-_Q1-Pad1_ Net-_Q13-Pad3_ eSim_NPN
Q14 Net-_Q13-Pad3_ Net-_Q13-Pad3_ Net-_Q11-Pad1_ eSim_NPN
Q19 Net-_Q17-Pad3_ Net-_Q19-Pad2_ Net-_Q1-Pad1_ eSim_PNP
Q17 Net-_Q17-Pad1_ Net-_Q11-Pad1_ Net-_Q17-Pad3_ eSim_PNP
Q5 Net-_Q10-Pad2_ Net-_Q10-Pad2_ Net-_Q10-Pad3_ eSim_NPN
D1 Net-_D1-Pad1_ Net-_D1-Pad2_ eSim_Diode
Q8 Net-_Q12-Pad3_ Net-_Q19-Pad2_ Net-_Q1-Pad1_ eSim_PNP
Q3 Net-_Q10-Pad2_ Net-_D1-Pad2_ Net-_Q12-Pad3_ eSim_PNP
Q2 Net-_Q10-Pad3_ Net-_D1-Pad1_ Net-_D1-Pad2_ eSim_PNP
Q10 Net-_Q10-Pad1_ Net-_Q10-Pad2_ Net-_Q10-Pad3_ eSim_NPN
.end
