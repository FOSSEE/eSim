.title KiCad schematic
I1 Net-_I1-Pad1_ Net-_I1-Pad2_ 50u
R12 Net-_Q12-Pad1_ Net-_Q15-Pad3_ 10k
Q15 Net-_Q13-Pad2_ Net-_I1-Pad2_ Net-_Q15-Pad3_ eSim_NPN
Q16 Net-_I1-Pad2_ Net-_I1-Pad2_ Net-_Q16-Pad3_ eSim_NPN
R13 Net-_Q12-Pad1_ Net-_Q16-Pad3_ 10k
R10 Net-_Q10-Pad3_ Net-_I1-Pad1_ 10k
R11 Net-_Q13-Pad3_ Net-_I1-Pad1_ 10k
Q14 Net-_Q13-Pad2_ Net-_Q13-Pad2_ Net-_I1-Pad1_ eSim_PNP
Q17 Net-_Q13-Pad3_ Net-_I1-Pad1_ Net-_Q17-Pad3_ eSim_NPN
R8 Net-_Q6-Pad3_ Net-_I1-Pad1_ 10k
U4 dv2 plot_v1
U5 dv1 plot_v1
U1 unconnected-_U1-Pad1_ Net-_I1-Pad1_ e Net-_Q12-Pad1_ Net-_R17-Pad1_ Net-_D1-Pad1_ unconnected-_U1-Pad7_ unconnected-_U1-Pad8_ PORT
R16 Net-_Q12-Pad1_ q19 10k
R17 Net-_R17-Pad1_ q19 100k
R15 q19 Net-_D1-Pad1_ 73k
Q19 Net-_Q17-Pad3_ Net-_Q18-Pad3_ Net-_D1-Pad1_ eSim_NPN
Q18 Net-_Q17-Pad3_ dv1 Net-_Q18-Pad3_ eSim_NPN
R14 Net-_Q17-Pad3_ Net-_I1-Pad1_ 1k
U2 e plot_v1
R3 Net-_Q1-Pad2_ q19 5k
R2 Net-_C1-Pad2_ Net-_D1-Pad2_ 51k
D1 Net-_D1-Pad1_ Net-_D1-Pad2_ eSim_Diode
Q2 Net-_C1-Pad2_ Net-_Q1-Pad2_ e eSim_NPN
R9 Net-_Q12-Pad1_ Net-_Q8-Pad3_ 10k
R6 Net-_R4-Pad2_ Net-_Q3-Pad3_ 1k
R7 Net-_Q12-Pad1_ Net-_R4-Pad2_ 10k
R4 Net-_Q12-Pad1_ Net-_R4-Pad2_ 10k
Q9 Net-_Q7-Pad3_ Net-_C1-Pad2_ Net-_Q5-Pad3_ eSim_NPN
Q8 Net-_Q5-Pad3_ Net-_I1-Pad2_ Net-_Q8-Pad3_ eSim_NPN
Q5 Net-_Q4-Pad3_ Net-_Q3-Pad1_ Net-_Q5-Pad3_ eSim_NPN
Q3 Net-_Q3-Pad1_ q19 Net-_Q3-Pad3_ eSim_NPN
R5 Net-_Q3-Pad1_ Net-_D1-Pad2_ 16k
U3 q19 plot_v1
Q4 Net-_Q11-Pad2_ Net-_D1-Pad2_ Net-_Q4-Pad3_ eSim_NPN
Q7 Net-_C1-Pad1_ Net-_D1-Pad2_ Net-_Q7-Pad3_ eSim_NPN
C1 Net-_C1-Pad1_ Net-_C1-Pad2_ 30p
Q12 Net-_Q12-Pad1_ Net-_C1-Pad1_ Net-_D3-Pad2_ eSim_PNP
D3 dv2 Net-_D3-Pad2_ eSim_Diode
Q11 Net-_C1-Pad1_ Net-_Q11-Pad2_ Net-_Q10-Pad1_ eSim_PNP
D2 dv1 dv2 eSim_Diode
Q6 Net-_Q11-Pad2_ Net-_Q10-Pad1_ Net-_Q6-Pad3_ eSim_PNP
Q10 Net-_Q10-Pad1_ Net-_Q10-Pad1_ Net-_Q10-Pad3_ eSim_PNP
Q13 dv1 Net-_Q13-Pad2_ Net-_Q13-Pad3_ eSim_PNP
Q1 Net-_C1-Pad2_ Net-_Q1-Pad2_ e eSim_NPN
R1 Net-_Q3-Pad3_ e 17k
.end
