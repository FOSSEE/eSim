.title KiCad schematic
Q3 Net-_D1-Pad1_ Net-_M1-Pad2_ Net-_Q1-Pad3_ eSim_NPN
Q4 Net-_D1-Pad2_ Net-_M1-Pad2_ Net-_Q1-Pad3_ eSim_NPN
U1 Net-_C1-Pad2_ Net-_M1-Pad2_ zener
M1 Net-_D1-Pad1_ Net-_M1-Pad2_ Net-_C1-Pad2_ Net-_C1-Pad2_ mosfet_n
Q1 Net-_D1-Pad1_ Net-_M1-Pad2_ Net-_Q1-Pad3_ eSim_NPN
Q2 Net-_D1-Pad1_ Net-_M1-Pad2_ Net-_Q1-Pad3_ eSim_NPN
R1 Net-_C1-Pad2_ Net-_Q1-Pad3_ 10k
Q11 Net-_D3-Pad1_ Net-_D1-Pad2_ Net-_D1-Pad1_ eSim_PNP
v4 Net-_D1-Pad1_ GND DC
Q13 Net-_D1-Pad1_ Net-_D3-Pad1_ Net-_C2-Pad2_ eSim_NPN
R7 Net-_C2-Pad2_ Net-_D3-Pad2_ 120
D3 Net-_D3-Pad1_ Net-_D3-Pad2_ diode
Q10 Net-_D3-Pad1_ Net-_C2-Pad1_ Net-_C3-Pad1_ eSim_NPN
v2 in2 GND DC
C2 Net-_C2-Pad1_ Net-_C2-Pad2_ 5p
Q8 Net-_C2-Pad1_ Net-_Q8-Pad2_ Net-_Q5-Pad3_ eSim_PNP
Q5 Net-_D2-Pad1_ in1 Net-_Q5-Pad3_ eSim_PNP
R3 Net-_Q6-Pad3_ Net-_D1-Pad1_ 5.6k
Q6 Net-_Q5-Pad3_ Net-_D1-Pad2_ Net-_Q6-Pad3_ eSim_PNP
R10 in2 Net-_Q8-Pad2_ 400k
U3 in2 plot_v1
R6 Net-_C1-Pad2_ Net-_Q12-Pad3_ 200
R4 Net-_C1-Pad2_ Net-_Q7-Pad3_ 10k
R2 Net-_C1-Pad2_ Net-_C1-Pad1_ 4.7k
C1 Net-_C1-Pad1_ Net-_C1-Pad2_ 10p
v3 GND Net-_C1-Pad2_ DC
Q9 Net-_C2-Pad1_ Net-_Q12-Pad3_ Net-_C1-Pad2_ eSim_NPN
R5 Net-_Q12-Pad3_ Net-_C3-Pad1_ 200
D2 Net-_D2-Pad1_ Net-_C1-Pad1_ diode
D1 Net-_D1-Pad1_ Net-_D1-Pad2_ diode
U2 in1 plot_v1
v1 in1 GND DC
C3 Net-_C3-Pad1_ Net-_C2-Pad2_ 10p
R8 Net-_C2-Pad2_ out 50
Q14 Net-_D3-Pad1_ Net-_C2-Pad2_ out eSim_NPN
R9 out GND 600
R11 out Net-_Q8-Pad2_ 600k
Q12 Net-_D3-Pad2_ Net-_C3-Pad1_ Net-_Q12-Pad3_ eSim_NPN
D4 out Net-_D3-Pad2_ diode
U4 out plot_v1
Q7 Net-_C2-Pad1_ Net-_D2-Pad1_ Net-_Q7-Pad3_ eSim_NPN
.end
