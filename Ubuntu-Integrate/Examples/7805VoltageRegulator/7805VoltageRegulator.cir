.title KiCad schematic
D1 in2 Net-_D1-Pad2_ eSim_Diode
U1 in1 plot_v1
U2 in2 plot_v1
v1 in1 in2 sine
D2 GND in2 eSim_Diode
C2 out GND 3.3u
X1 Net-_D1-Pad2_ GND out Lm_7805
D5 GND out eSim_Diode
R1 out GND 1k
D3 in1 Net-_D1-Pad2_ eSim_Diode
D4 GND in1 eSim_Diode
C1 Net-_D1-Pad2_ GND 1000u
U3 out plot_v1
.end
