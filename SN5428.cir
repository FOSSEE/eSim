.title KiCad schematic
U10 Net-_U10-Pad1_ Net-_U10-Pad2_ Net-_U10-Pad3_ d_xnor
U11 Net-_U11-Pad1_ Net-_U11-Pad2_ Net-_U11-Pad3_ d_xnor
U12 Net-_U12-Pad1_ Net-_U12-Pad2_ Net-_U12-Pad3_ d_xnor
U13 Net-_U13-Pad1_ Net-_U13-Pad2_ Net-_U13-Pad3_ d_xnor
U18 a plot_v1
U17 b plot_v1
U15 d plot_v1
U16 c plot_v1
U14 Net-_U12-Pad3_ Net-_U13-Pad3_ Net-_U10-Pad3_ Net-_U11-Pad3_ a b c d dac_bridge_4
U9 i1 i2 i3 i4 i5 i6 i7 i8 Net-_U12-Pad1_ Net-_U12-Pad2_ Net-_U13-Pad1_ Net-_U13-Pad2_ Net-_U10-Pad1_ Net-_U10-Pad2_ Net-_U11-Pad1_ Net-_U11-Pad2_ adc_bridge_8
U8 i1 plot_v1
v3 i4 GND pulse
v4 i3 GND pulse
v8 i1 GND pulse
v7 i2 GND pulse
U7 i2 plot_v1
U6 i8 plot_v1
U4 i7 plot_v1
U1 i5 plot_v1
U2 i6 plot_v1
v2 i6 GND pulse
v1 i5 GND pulse
v6 i8 GND pulse
v5 i7 GND pulse
U5 i3 plot_v1
U3 i4 plot_v1
.end
