.title KiCad schematic
U31 Net-_U23-Pad2_ Net-_U31-Pad2_ d_inverter
U32 Net-_U24-Pad2_ Net-_U32-Pad2_ d_inverter
U33 Net-_U25-Pad2_ Net-_U33-Pad2_ d_inverter
U29 Net-_U20-Pad2_ Net-_U29-Pad2_ d_buffer
U30 Net-_U21-Pad2_ Net-_U30-Pad2_ d_inverter
U25 Net-_U14-Pad2_ Net-_U25-Pad2_ d_buffer
U26 Net-_U16-Pad2_ Net-_U26-Pad2_ d_buffer
U24 Net-_U13-Pad2_ Net-_U24-Pad2_ d_buffer
U21 Net-_U11-Pad2_ Net-_U21-Pad2_ d_buffer
U23 Net-_U12-Pad2_ Net-_U23-Pad2_ d_buffer
U22 Net-_U15-Pad2_ Net-_U22-Pad2_ d_buffer
U20 Net-_U20-Pad1_ Net-_U20-Pad2_ d_inverter
U28 Net-_U19-Pad2_ Net-_U28-Pad2_ d_buffer
U27 Net-_U18-Pad2_ Net-_U27-Pad2_ d_buffer
U17 i6 i7 i8 i9 Net-_U14-Pad1_ Net-_U16-Pad1_ Net-_U17-Pad7_ Net-_U17-Pad8_ adc_bridge_4
U18 Net-_U17-Pad8_ Net-_U18-Pad2_ d_inverter
U19 Net-_U17-Pad7_ Net-_U19-Pad2_ d_inverter
U9 i8 plot_v1
U8 i7 plot_v1
U10 i9 plot_v1
U7 i6 plot_v1
U35 Net-_U29-Pad2_ Net-_U30-Pad2_ Net-_U35-Pad3_ d_and
U34 Net-_U28-Pad2_ Net-_U27-Pad2_ Net-_U34-Pad3_ d_nor
U14 Net-_U14-Pad1_ Net-_U14-Pad2_ d_inverter
U4 i1 i2 i3 i4 i5 Net-_U20-Pad1_ Net-_U11-Pad1_ Net-_U15-Pad1_ Net-_U12-Pad1_ Net-_U13-Pad1_ adc_bridge_5
U16 Net-_U16-Pad1_ Net-_U16-Pad2_ d_inverter
U5 i4 plot_v1
U6 i5 plot_v1
U2 i2 plot_v1
U3 i3 plot_v1
U1 i1 plot_v1
U11 Net-_U11-Pad1_ Net-_U11-Pad2_ d_inverter
U15 Net-_U15-Pad1_ Net-_U15-Pad2_ d_inverter
U13 Net-_U13-Pad1_ Net-_U13-Pad2_ d_inverter
U12 Net-_U12-Pad1_ Net-_U12-Pad2_ d_inverter
v3 i3 GND pulse
v1 i1 GND pulse
v4 i4 GND pulse
v5 i5 GND pulse
v2 i2 GND pulse
v9 i9 GND pulse
v7 i7 GND pulse
v8 i8 GND pulse
v6 i6 GND pulse
U38 Net-_U22-Pad2_ Net-_U34-Pad3_ Net-_U38-Pad3_ d_and
U37 Net-_U31-Pad2_ Net-_U33-Pad2_ Net-_U37-Pad3_ d_and
U39 Net-_U24-Pad2_ Net-_U33-Pad2_ Net-_U39-Pad3_ d_and
U40 Net-_U26-Pad2_ Net-_U34-Pad3_ Net-_U40-Pad3_ d_and
U36 Net-_U31-Pad2_ Net-_U33-Pad2_ Net-_U36-Pad3_ d_and
U44 Net-_U32-Pad2_ Net-_U22-Pad2_ Net-_U44-Pad3_ d_and
U41 Net-_U27-Pad2_ Net-_U34-Pad3_ Net-_U41-Pad3_ d_and
U43 Net-_U32-Pad2_ Net-_U34-Pad3_ Net-_U43-Pad3_ d_and
U42 Net-_U21-Pad2_ Net-_U31-Pad2_ Net-_U42-Pad3_ d_and
U45 Net-_U31-Pad2_ Net-_U34-Pad3_ Net-_U45-Pad3_ d_and
U59 Net-_U35-Pad3_ Net-_U36-Pad3_ Net-_U59-Pad3_ d_and
U53 Net-_U37-Pad3_ Net-_U38-Pad3_ Net-_U53-Pad3_ d_and
U64 Net-_U63-Pad3_ Net-_U53-Pad3_ Net-_U64-Pad3_ d_or
U63 Net-_U59-Pad3_ Net-_U34-Pad3_ Net-_U63-Pad3_ d_and
U65 Net-_U58-Pad3_ Net-_U40-Pad3_ Net-_U65-Pad3_ d_or
U58 Net-_U39-Pad3_ Net-_U34-Pad3_ Net-_U58-Pad3_ d_and
U68 Net-_U64-Pad3_ Net-_U65-Pad3_ Net-_U68-Pad3_ d_or
U67 Net-_U60-Pad3_ Net-_U61-Pad3_ Net-_U67-Pad3_ d_or
U60 Net-_U54-Pad3_ Net-_U55-Pad3_ Net-_U60-Pad3_ d_or
U54 Net-_U42-Pad3_ Net-_U43-Pad3_ Net-_U54-Pad3_ d_and
U55 Net-_U44-Pad3_ Net-_U45-Pad3_ Net-_U55-Pad3_ d_and
U61 Net-_U46-Pad3_ Net-_U47-Pad3_ Net-_U61-Pad3_ d_or
U70 Net-_U67-Pad3_ Net-_U70-Pad2_ d_inverter
U66 Net-_U62-Pad3_ Net-_U66-Pad2_ d_inverter
U62 Net-_U56-Pad3_ Net-_U57-Pad3_ Net-_U62-Pad3_ d_or
U75 B plot_v1
U76 A plot_v1
U74 C plot_v1
U72 D plot_v1
U69 Net-_U68-Pad3_ Net-_U41-Pad3_ Net-_U69-Pad3_ d_or
U71 Net-_U69-Pad3_ Net-_U71-Pad2_ d_inverter
U73 Net-_U71-Pad2_ Net-_U70-Pad2_ Net-_U66-Pad2_ Net-_U52-Pad3_ A B C D dac_bridge_4
U56 Net-_U48-Pad3_ Net-_U49-Pad3_ Net-_U56-Pad3_ d_or
U52 Net-_U28-Pad2_ Net-_U27-Pad2_ Net-_U52-Pad3_ d_nor
U57 Net-_U50-Pad3_ Net-_U51-Pad3_ Net-_U57-Pad3_ d_or
U51 Net-_U26-Pad2_ Net-_U34-Pad3_ Net-_U51-Pad3_ d_and
U49 Net-_U24-Pad2_ Net-_U34-Pad3_ Net-_U49-Pad3_ d_and
U50 Net-_U25-Pad2_ Net-_U34-Pad3_ Net-_U50-Pad3_ d_and
U48 Net-_U23-Pad2_ Net-_U34-Pad3_ Net-_U48-Pad3_ d_and
U46 Net-_U25-Pad2_ Net-_U34-Pad3_ Net-_U46-Pad3_ d_and
U47 Net-_U26-Pad2_ Net-_U34-Pad3_ Net-_U47-Pad3_ d_and
.end
